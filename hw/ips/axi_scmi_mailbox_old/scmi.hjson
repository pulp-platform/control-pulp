// Copyright lowRISC contributors.
// Licensed under the Apache License, Version 2.0, see LICENSE for details.
// SPDX-License-Identifier: Apache-2.0
# SCMI register template
# - src: Number of mailbox channels. Following is the memory layout of one channel.
{
  name: "scmi",
  clock_primary: "clk_i",
  bus_interfaces: [
        { protocol: "reg_iface", direction: "device"}
    ],
  regwidth: "32",
  registers: [
    { name: "Reserved_1_c0",
      desc: "Reserved, must be 0",
      swaccess: "rw",
      hwaccess: "none",
      fields: [
        { bits: "31:0" }
      ],
    },
    { name: "Channel_Status_c0",
      desc: "Indicates which entity has access to the Shared Memory",
      swaccess: "rw",
      hwaccess: "none",
      fields: [
        { bits: "31:2" },
        { bits: "1",
          name: "channel_error",
          desc: "Must be 0 in absence of errors"
        },
        { bits: "0",
          name: "channel_free",
          desc: "If 1 the agent own the channel, if 0 the platform own the channel"
        }
      ],
    },
    { name: "Reserved_2_c0",
      desc: "Reserved, implementation defined (32 bits over 64)",
      swaccess: "rw",
      hwaccess: "none",
      fields: [
        { bits: "31:0" }
      ],
    },
    { name: "Reserved_3_c0",
      desc: "Reserved, implementation defined (32 bits over 64)",
      swaccess: "none",
      hwaccess: "none",
      fields: [
        { bits: "31:0" }
      ],
    },
    { name: "Channel_Flags_c0",
      desc: "Defines wheter interrupts or polling is used for communication",
      swaccess: "rw",
      hwaccess: "none",
      fields: [
        { bits: "31:1" },
        { bits: "0",
          name: "intr_enable",
          desc: "If 1 interruts are used, if 0 polling is used"
        }
      ],
    },
    { name: "Length_c0",
      desc: "Lenght of payload + header",
      swaccess: "rw",
      hwaccess: "none",
      fields: [
        { bits: "31:0" }
      ],
    },
    { name: "Message_Header_c0",
      desc: "Defines which commanad the message contains",
      swaccess: "rw",
      hwaccess: "none",
      fields: [
        { bits: "31:28" },
        { bits: "27:18",
          name: "Token",
          desc: "must be same for the msg responses associated to a msg whith the same header"
        },
        { bits: "17:10",
          name: "Protocol_Id",
          desc: "Identifies to which protocol the command belongs to"
        },
        { bits: "9:8",
          name: "Message_Type",
          desc: "can be 0,1,2,3 depending on the kind of msg to be sent"
        },
        { bits: "7:0",
          name: "Message_Id",
          desc: "unique identifier for each command availabe in the protocol pointed by protocol_id"
        }
      ],
    },
    { name: "Message_Payload_1_c0",
      desc: "memory region dedicated to the parameters of the commands and their returns",
      swaccess: "rw",
      hwaccess: "none",
      fields: [
        { bits: "31:0" }
      ],
    },
    { name: "Doorbell_c0",
      desc: "Rapresents the interrupt to be raised towards the platform",
      swaccess: "rw",
      hwaccess: "hro",
      fields: [
        { bits: "31:1",
          name: "Preserve_Mask",
          desc: "These bits must be constant to 0, not used with just one platform and one agent"
        },
        { bits: "0",
          name: "intr",
          desc: "Interrupt bit"
        }
      ],
    },
    { name:  "Completion_Interrupt_c0",
      desc: "Rapresent the interrupt the platform should raise when it finishes to execute the received command",
      swaccess: "rw",
      hwaccess: "hro",
      fields: [
        { bits: "31:1",
          name: "Preserve_Mask",
          desc: "These bits must be constant to 0, not used with just one platform and one agent"
        },
        { bits: "0",
          name: "intr",
          desc: "Interrupt bit"
        }
      ],
    },
    { name: "Reserved_1_c1",
      desc: "Reserved, must be 0",
      swaccess: "rw",
      hwaccess: "none",
      fields: [
        { bits: "31:0" }
      ],
    },
    { name: "Channel_Status_c1",
      desc: "Indicates which entity has access to the Shared Memory",
      swaccess: "rw",
      hwaccess: "none",
      fields: [
        { bits: "31:2" },
        { bits: "1",
          name: "channel_error",
          desc: "Must be 0 in absence of errors"
        },
        { bits: "0",
          name: "channel_free",
          desc: "If 1 the agent own the channel, if 0 the platform own the channel"
        }
      ],
    },
    { name: "Reserved_2_c1",
      desc: "Reserved, implementation defined (32 bits over 64)",
      swaccess: "rw",
      hwaccess: "none",
      fields: [
        { bits: "31:0" }
      ],
    },
    { name: "Reserved_3_c1",
      desc: "Reserved, implementation defined (32 bits over 64)",
      swaccess: "none",
      hwaccess: "none",
      fields: [
        { bits: "31:0" }
      ],
    },
    { name: "Channel_Flags_c1",
      desc: "Defines wheter interrupts or polling is used for communication",
      swaccess: "rw",
      hwaccess: "none",
      fields: [
        { bits: "31:1" },
        { bits: "0",
          name: "intr_enable",
          desc: "If 1 interruts are used, if 0 polling is used"
        }
      ],
    },
    { name: "Length_c1",
      desc: "Lenght of payload + header",
      swaccess: "rw",
      hwaccess: "none",
      fields: [
        { bits: "31:0" }
      ],
    },
    { name: "Message_Header_c1",
      desc: "Defines which commanad the message contains",
      swaccess: "rw",
      hwaccess: "none",
      fields: [
        { bits: "31:28" },
        { bits: "27:18",
          name: "Token",
          desc: "must be same for the msg responses associated to a msg whith the same header"
        },
        { bits: "17:10",
          name: "Protocol_Id",
          desc: "Identifies to which protocol the command belongs to"
        },
        { bits: "9:8",
          name: "Message_Type",
          desc: "can be 0,1,2,3 depending on the kind of msg to be sent"
        },
        { bits: "7:0",
          name: "Message_Id",
          desc: "unique identifier for each command availabe in the protocol pointed by protocol_id"
        }
      ],
    },
    { name: "Message_Payload_1_c1",
      desc: "memory region dedicated to the parameters of the commands and their returns",
      swaccess: "rw",
      hwaccess: "none",
      fields: [
        { bits: "31:0" }
      ],
    },
    { name: "Doorbell_c1",
      desc: "Rapresents the interrupt to be raised towards the platform",
      swaccess: "rw",
      hwaccess: "hro",
      fields: [
        { bits: "31:1",
          name: "Preserve_Mask",
          desc: "These bits must be constant to 0, not used with just one platform and one agent"
        },
        { bits: "0",
          name: "intr",
          desc: "Interrupt bit"
        }
      ],
    },
    { name:  "Completion_Interrupt_c1",
      desc: "Rapresent the interrupt the platform should raise when it finishes to execute the received command",
      swaccess: "rw",
      hwaccess: "hro",
      fields: [
        { bits: "31:1",
          name: "Preserve_Mask",
          desc: "These bits must be constant to 0, not used with just one platform and one agent"
        },
        { bits: "0",
          name: "intr",
          desc: "Interrupt bit"
        }
      ],
    },
    { name: "Reserved_1_c2",
      desc: "Reserved, must be 0",
      swaccess: "rw",
      hwaccess: "none",
      fields: [
        { bits: "31:0" }
      ],
    },
    { name: "Channel_Status_c2",
      desc: "Indicates which entity has access to the Shared Memory",
      swaccess: "rw",
      hwaccess: "none",
      fields: [
        { bits: "31:2" },
        { bits: "1",
          name: "channel_error",
          desc: "Must be 0 in absence of errors"
        },
        { bits: "0",
          name: "channel_free",
          desc: "If 1 the agent own the channel, if 0 the platform own the channel"
        }
      ],
    },
    { name: "Reserved_2_c2",
      desc: "Reserved, implementation defined (32 bits over 64)",
      swaccess: "rw",
      hwaccess: "none",
      fields: [
        { bits: "31:0" }
      ],
    },
    { name: "Reserved_3_c2",
      desc: "Reserved, implementation defined (32 bits over 64)",
      swaccess: "none",
      hwaccess: "none",
      fields: [
        { bits: "31:0" }
      ],
    },
    { name: "Channel_Flags_c2",
      desc: "Defines wheter interrupts or polling is used for communication",
      swaccess: "rw",
      hwaccess: "none",
      fields: [
        { bits: "31:1" },
        { bits: "0",
          name: "intr_enable",
          desc: "If 1 interruts are used, if 0 polling is used"
        }
      ],
    },
    { name: "Length_c2",
      desc: "Lenght of payload + header",
      swaccess: "rw",
      hwaccess: "none",
      fields: [
        { bits: "31:0" }
      ],
    },
    { name: "Message_Header_c2",
      desc: "Defines which commanad the message contains",
      swaccess: "rw",
      hwaccess: "none",
      fields: [
        { bits: "31:28" },
        { bits: "27:18",
          name: "Token",
          desc: "must be same for the msg responses associated to a msg whith the same header"
        },
        { bits: "17:10",
          name: "Protocol_Id",
          desc: "Identifies to which protocol the command belongs to"
        },
        { bits: "9:8",
          name: "Message_Type",
          desc: "can be 0,1,2,3 depending on the kind of msg to be sent"
        },
        { bits: "7:0",
          name: "Message_Id",
          desc: "unique identifier for each command availabe in the protocol pointed by protocol_id"
        }
      ],
    },
    { name: "Message_Payload_1_c2",
      desc: "memory region dedicated to the parameters of the commands and their returns",
      swaccess: "rw",
      hwaccess: "none",
      fields: [
        { bits: "31:0" }
      ],
    },
    { name: "Doorbell_c2",
      desc: "Rapresents the interrupt to be raised towards the platform",
      swaccess: "rw",
      hwaccess: "hro",
      fields: [
        { bits: "31:1",
          name: "Preserve_Mask",
          desc: "These bits must be constant to 0, not used with just one platform and one agent"
        },
        { bits: "0",
          name: "intr",
          desc: "Interrupt bit"
        }
      ],
    },
    { name:  "Completion_Interrupt_c2",
      desc: "Rapresent the interrupt the platform should raise when it finishes to execute the received command",
      swaccess: "rw",
      hwaccess: "hro",
      fields: [
        { bits: "31:1",
          name: "Preserve_Mask",
          desc: "These bits must be constant to 0, not used with just one platform and one agent"
        },
        { bits: "0",
          name: "intr",
          desc: "Interrupt bit"
        }
      ],
    },
    { name: "Reserved_1_c3",
      desc: "Reserved, must be 0",
      swaccess: "rw",
      hwaccess: "none",
      fields: [
        { bits: "31:0" }
      ],
    },
    { name: "Channel_Status_c3",
      desc: "Indicates which entity has access to the Shared Memory",
      swaccess: "rw",
      hwaccess: "none",
      fields: [
        { bits: "31:2" },
        { bits: "1",
          name: "channel_error",
          desc: "Must be 0 in absence of errors"
        },
        { bits: "0",
          name: "channel_free",
          desc: "If 1 the agent own the channel, if 0 the platform own the channel"
        }
      ],
    },
    { name: "Reserved_2_c3",
      desc: "Reserved, implementation defined (32 bits over 64)",
      swaccess: "rw",
      hwaccess: "none",
      fields: [
        { bits: "31:0" }
      ],
    },
    { name: "Reserved_3_c3",
      desc: "Reserved, implementation defined (32 bits over 64)",
      swaccess: "none",
      hwaccess: "none",
      fields: [
        { bits: "31:0" }
      ],
    },
    { name: "Channel_Flags_c3",
      desc: "Defines wheter interrupts or polling is used for communication",
      swaccess: "rw",
      hwaccess: "none",
      fields: [
        { bits: "31:1" },
        { bits: "0",
          name: "intr_enable",
          desc: "If 1 interruts are used, if 0 polling is used"
        }
      ],
    },
    { name: "Length_c3",
      desc: "Lenght of payload + header",
      swaccess: "rw",
      hwaccess: "none",
      fields: [
        { bits: "31:0" }
      ],
    },
    { name: "Message_Header_c3",
      desc: "Defines which commanad the message contains",
      swaccess: "rw",
      hwaccess: "none",
      fields: [
        { bits: "31:28" },
        { bits: "27:18",
          name: "Token",
          desc: "must be same for the msg responses associated to a msg whith the same header"
        },
        { bits: "17:10",
          name: "Protocol_Id",
          desc: "Identifies to which protocol the command belongs to"
        },
        { bits: "9:8",
          name: "Message_Type",
          desc: "can be 0,1,2,3 depending on the kind of msg to be sent"
        },
        { bits: "7:0",
          name: "Message_Id",
          desc: "unique identifier for each command availabe in the protocol pointed by protocol_id"
        }
      ],
    },
    { name: "Message_Payload_1_c3",
      desc: "memory region dedicated to the parameters of the commands and their returns",
      swaccess: "rw",
      hwaccess: "none",
      fields: [
        { bits: "31:0" }
      ],
    },
    { name: "Doorbell_c3",
      desc: "Rapresents the interrupt to be raised towards the platform",
      swaccess: "rw",
      hwaccess: "hro",
      fields: [
        { bits: "31:1",
          name: "Preserve_Mask",
          desc: "These bits must be constant to 0, not used with just one platform and one agent"
        },
        { bits: "0",
          name: "intr",
          desc: "Interrupt bit"
        }
      ],
    },
    { name:  "Completion_Interrupt_c3",
      desc: "Rapresent the interrupt the platform should raise when it finishes to execute the received command",
      swaccess: "rw",
      hwaccess: "hro",
      fields: [
        { bits: "31:1",
          name: "Preserve_Mask",
          desc: "These bits must be constant to 0, not used with just one platform and one agent"
        },
        { bits: "0",
          name: "intr",
          desc: "Interrupt bit"
        }
      ],
    },
    { name: "Reserved_1_c4",
      desc: "Reserved, must be 0",
      swaccess: "rw",
      hwaccess: "none",
      fields: [
        { bits: "31:0" }
      ],
    },
    { name: "Channel_Status_c4",
      desc: "Indicates which entity has access to the Shared Memory",
      swaccess: "rw",
      hwaccess: "none",
      fields: [
        { bits: "31:2" },
        { bits: "1",
          name: "channel_error",
          desc: "Must be 0 in absence of errors"
        },
        { bits: "0",
          name: "channel_free",
          desc: "If 1 the agent own the channel, if 0 the platform own the channel"
        }
      ],
    },
    { name: "Reserved_2_c4",
      desc: "Reserved, implementation defined (32 bits over 64)",
      swaccess: "rw",
      hwaccess: "none",
      fields: [
        { bits: "31:0" }
      ],
    },
    { name: "Reserved_3_c4",
      desc: "Reserved, implementation defined (32 bits over 64)",
      swaccess: "none",
      hwaccess: "none",
      fields: [
        { bits: "31:0" }
      ],
    },
    { name: "Channel_Flags_c4",
      desc: "Defines wheter interrupts or polling is used for communication",
      swaccess: "rw",
      hwaccess: "none",
      fields: [
        { bits: "31:1" },
        { bits: "0",
          name: "intr_enable",
          desc: "If 1 interruts are used, if 0 polling is used"
        }
      ],
    },
    { name: "Length_c4",
      desc: "Lenght of payload + header",
      swaccess: "rw",
      hwaccess: "none",
      fields: [
        { bits: "31:0" }
      ],
    },
    { name: "Message_Header_c4",
      desc: "Defines which commanad the message contains",
      swaccess: "rw",
      hwaccess: "none",
      fields: [
        { bits: "31:28" },
        { bits: "27:18",
          name: "Token",
          desc: "must be same for the msg responses associated to a msg whith the same header"
        },
        { bits: "17:10",
          name: "Protocol_Id",
          desc: "Identifies to which protocol the command belongs to"
        },
        { bits: "9:8",
          name: "Message_Type",
          desc: "can be 0,1,2,3 depending on the kind of msg to be sent"
        },
        { bits: "7:0",
          name: "Message_Id",
          desc: "unique identifier for each command availabe in the protocol pointed by protocol_id"
        }
      ],
    },
    { name: "Message_Payload_1_c4",
      desc: "memory region dedicated to the parameters of the commands and their returns",
      swaccess: "rw",
      hwaccess: "none",
      fields: [
        { bits: "31:0" }
      ],
    },
    { name: "Doorbell_c4",
      desc: "Rapresents the interrupt to be raised towards the platform",
      swaccess: "rw",
      hwaccess: "hro",
      fields: [
        { bits: "31:1",
          name: "Preserve_Mask",
          desc: "These bits must be constant to 0, not used with just one platform and one agent"
        },
        { bits: "0",
          name: "intr",
          desc: "Interrupt bit"
        }
      ],
    },
    { name:  "Completion_Interrupt_c4",
      desc: "Rapresent the interrupt the platform should raise when it finishes to execute the received command",
      swaccess: "rw",
      hwaccess: "hro",
      fields: [
        { bits: "31:1",
          name: "Preserve_Mask",
          desc: "These bits must be constant to 0, not used with just one platform and one agent"
        },
        { bits: "0",
          name: "intr",
          desc: "Interrupt bit"
        }
      ],
    },
    { name: "Reserved_1_c5",
      desc: "Reserved, must be 0",
      swaccess: "rw",
      hwaccess: "none",
      fields: [
        { bits: "31:0" }
      ],
    },
    { name: "Channel_Status_c5",
      desc: "Indicates which entity has access to the Shared Memory",
      swaccess: "rw",
      hwaccess: "none",
      fields: [
        { bits: "31:2" },
        { bits: "1",
          name: "channel_error",
          desc: "Must be 0 in absence of errors"
        },
        { bits: "0",
          name: "channel_free",
          desc: "If 1 the agent own the channel, if 0 the platform own the channel"
        }
      ],
    },
    { name: "Reserved_2_c5",
      desc: "Reserved, implementation defined (32 bits over 64)",
      swaccess: "rw",
      hwaccess: "none",
      fields: [
        { bits: "31:0" }
      ],
    },
    { name: "Reserved_3_c5",
      desc: "Reserved, implementation defined (32 bits over 64)",
      swaccess: "none",
      hwaccess: "none",
      fields: [
        { bits: "31:0" }
      ],
    },
    { name: "Channel_Flags_c5",
      desc: "Defines wheter interrupts or polling is used for communication",
      swaccess: "rw",
      hwaccess: "none",
      fields: [
        { bits: "31:1" },
        { bits: "0",
          name: "intr_enable",
          desc: "If 1 interruts are used, if 0 polling is used"
        }
      ],
    },
    { name: "Length_c5",
      desc: "Lenght of payload + header",
      swaccess: "rw",
      hwaccess: "none",
      fields: [
        { bits: "31:0" }
      ],
    },
    { name: "Message_Header_c5",
      desc: "Defines which commanad the message contains",
      swaccess: "rw",
      hwaccess: "none",
      fields: [
        { bits: "31:28" },
        { bits: "27:18",
          name: "Token",
          desc: "must be same for the msg responses associated to a msg whith the same header"
        },
        { bits: "17:10",
          name: "Protocol_Id",
          desc: "Identifies to which protocol the command belongs to"
        },
        { bits: "9:8",
          name: "Message_Type",
          desc: "can be 0,1,2,3 depending on the kind of msg to be sent"
        },
        { bits: "7:0",
          name: "Message_Id",
          desc: "unique identifier for each command availabe in the protocol pointed by protocol_id"
        }
      ],
    },
    { name: "Message_Payload_1_c5",
      desc: "memory region dedicated to the parameters of the commands and their returns",
      swaccess: "rw",
      hwaccess: "none",
      fields: [
        { bits: "31:0" }
      ],
    },
    { name: "Doorbell_c5",
      desc: "Rapresents the interrupt to be raised towards the platform",
      swaccess: "rw",
      hwaccess: "hro",
      fields: [
        { bits: "31:1",
          name: "Preserve_Mask",
          desc: "These bits must be constant to 0, not used with just one platform and one agent"
        },
        { bits: "0",
          name: "intr",
          desc: "Interrupt bit"
        }
      ],
    },
    { name:  "Completion_Interrupt_c5",
      desc: "Rapresent the interrupt the platform should raise when it finishes to execute the received command",
      swaccess: "rw",
      hwaccess: "hro",
      fields: [
        { bits: "31:1",
          name: "Preserve_Mask",
          desc: "These bits must be constant to 0, not used with just one platform and one agent"
        },
        { bits: "0",
          name: "intr",
          desc: "Interrupt bit"
        }
      ],
    },
    { name: "Reserved_1_c6",
      desc: "Reserved, must be 0",
      swaccess: "rw",
      hwaccess: "none",
      fields: [
        { bits: "31:0" }
      ],
    },
    { name: "Channel_Status_c6",
      desc: "Indicates which entity has access to the Shared Memory",
      swaccess: "rw",
      hwaccess: "none",
      fields: [
        { bits: "31:2" },
        { bits: "1",
          name: "channel_error",
          desc: "Must be 0 in absence of errors"
        },
        { bits: "0",
          name: "channel_free",
          desc: "If 1 the agent own the channel, if 0 the platform own the channel"
        }
      ],
    },
    { name: "Reserved_2_c6",
      desc: "Reserved, implementation defined (32 bits over 64)",
      swaccess: "rw",
      hwaccess: "none",
      fields: [
        { bits: "31:0" }
      ],
    },
    { name: "Reserved_3_c6",
      desc: "Reserved, implementation defined (32 bits over 64)",
      swaccess: "none",
      hwaccess: "none",
      fields: [
        { bits: "31:0" }
      ],
    },
    { name: "Channel_Flags_c6",
      desc: "Defines wheter interrupts or polling is used for communication",
      swaccess: "rw",
      hwaccess: "none",
      fields: [
        { bits: "31:1" },
        { bits: "0",
          name: "intr_enable",
          desc: "If 1 interruts are used, if 0 polling is used"
        }
      ],
    },
    { name: "Length_c6",
      desc: "Lenght of payload + header",
      swaccess: "rw",
      hwaccess: "none",
      fields: [
        { bits: "31:0" }
      ],
    },
    { name: "Message_Header_c6",
      desc: "Defines which commanad the message contains",
      swaccess: "rw",
      hwaccess: "none",
      fields: [
        { bits: "31:28" },
        { bits: "27:18",
          name: "Token",
          desc: "must be same for the msg responses associated to a msg whith the same header"
        },
        { bits: "17:10",
          name: "Protocol_Id",
          desc: "Identifies to which protocol the command belongs to"
        },
        { bits: "9:8",
          name: "Message_Type",
          desc: "can be 0,1,2,3 depending on the kind of msg to be sent"
        },
        { bits: "7:0",
          name: "Message_Id",
          desc: "unique identifier for each command availabe in the protocol pointed by protocol_id"
        }
      ],
    },
    { name: "Message_Payload_1_c6",
      desc: "memory region dedicated to the parameters of the commands and their returns",
      swaccess: "rw",
      hwaccess: "none",
      fields: [
        { bits: "31:0" }
      ],
    },
    { name: "Doorbell_c6",
      desc: "Rapresents the interrupt to be raised towards the platform",
      swaccess: "rw",
      hwaccess: "hro",
      fields: [
        { bits: "31:1",
          name: "Preserve_Mask",
          desc: "These bits must be constant to 0, not used with just one platform and one agent"
        },
        { bits: "0",
          name: "intr",
          desc: "Interrupt bit"
        }
      ],
    },
    { name:  "Completion_Interrupt_c6",
      desc: "Rapresent the interrupt the platform should raise when it finishes to execute the received command",
      swaccess: "rw",
      hwaccess: "hro",
      fields: [
        { bits: "31:1",
          name: "Preserve_Mask",
          desc: "These bits must be constant to 0, not used with just one platform and one agent"
        },
        { bits: "0",
          name: "intr",
          desc: "Interrupt bit"
        }
      ],
    },
    { name: "Reserved_1_c7",
      desc: "Reserved, must be 0",
      swaccess: "rw",
      hwaccess: "none",
      fields: [
        { bits: "31:0" }
      ],
    },
    { name: "Channel_Status_c7",
      desc: "Indicates which entity has access to the Shared Memory",
      swaccess: "rw",
      hwaccess: "none",
      fields: [
        { bits: "31:2" },
        { bits: "1",
          name: "channel_error",
          desc: "Must be 0 in absence of errors"
        },
        { bits: "0",
          name: "channel_free",
          desc: "If 1 the agent own the channel, if 0 the platform own the channel"
        }
      ],
    },
    { name: "Reserved_2_c7",
      desc: "Reserved, implementation defined (32 bits over 64)",
      swaccess: "rw",
      hwaccess: "none",
      fields: [
        { bits: "31:0" }
      ],
    },
    { name: "Reserved_3_c7",
      desc: "Reserved, implementation defined (32 bits over 64)",
      swaccess: "none",
      hwaccess: "none",
      fields: [
        { bits: "31:0" }
      ],
    },
    { name: "Channel_Flags_c7",
      desc: "Defines wheter interrupts or polling is used for communication",
      swaccess: "rw",
      hwaccess: "none",
      fields: [
        { bits: "31:1" },
        { bits: "0",
          name: "intr_enable",
          desc: "If 1 interruts are used, if 0 polling is used"
        }
      ],
    },
    { name: "Length_c7",
      desc: "Lenght of payload + header",
      swaccess: "rw",
      hwaccess: "none",
      fields: [
        { bits: "31:0" }
      ],
    },
    { name: "Message_Header_c7",
      desc: "Defines which commanad the message contains",
      swaccess: "rw",
      hwaccess: "none",
      fields: [
        { bits: "31:28" },
        { bits: "27:18",
          name: "Token",
          desc: "must be same for the msg responses associated to a msg whith the same header"
        },
        { bits: "17:10",
          name: "Protocol_Id",
          desc: "Identifies to which protocol the command belongs to"
        },
        { bits: "9:8",
          name: "Message_Type",
          desc: "can be 0,1,2,3 depending on the kind of msg to be sent"
        },
        { bits: "7:0",
          name: "Message_Id",
          desc: "unique identifier for each command availabe in the protocol pointed by protocol_id"
        }
      ],
    },
    { name: "Message_Payload_1_c7",
      desc: "memory region dedicated to the parameters of the commands and their returns",
      swaccess: "rw",
      hwaccess: "none",
      fields: [
        { bits: "31:0" }
      ],
    },
    { name: "Doorbell_c7",
      desc: "Rapresents the interrupt to be raised towards the platform",
      swaccess: "rw",
      hwaccess: "hro",
      fields: [
        { bits: "31:1",
          name: "Preserve_Mask",
          desc: "These bits must be constant to 0, not used with just one platform and one agent"
        },
        { bits: "0",
          name: "intr",
          desc: "Interrupt bit"
        }
      ],
    },
    { name:  "Completion_Interrupt_c7",
      desc: "Rapresent the interrupt the platform should raise when it finishes to execute the received command",
      swaccess: "rw",
      hwaccess: "hro",
      fields: [
        { bits: "31:1",
          name: "Preserve_Mask",
          desc: "These bits must be constant to 0, not used with just one platform and one agent"
        },
        { bits: "0",
          name: "intr",
          desc: "Interrupt bit"
        }
      ],
    },
    { name: "Reserved_1_c8",
      desc: "Reserved, must be 0",
      swaccess: "rw",
      hwaccess: "none",
      fields: [
        { bits: "31:0" }
      ],
    },
    { name: "Channel_Status_c8",
      desc: "Indicates which entity has access to the Shared Memory",
      swaccess: "rw",
      hwaccess: "none",
      fields: [
        { bits: "31:2" },
        { bits: "1",
          name: "channel_error",
          desc: "Must be 0 in absence of errors"
        },
        { bits: "0",
          name: "channel_free",
          desc: "If 1 the agent own the channel, if 0 the platform own the channel"
        }
      ],
    },
    { name: "Reserved_2_c8",
      desc: "Reserved, implementation defined (32 bits over 64)",
      swaccess: "rw",
      hwaccess: "none",
      fields: [
        { bits: "31:0" }
      ],
    },
    { name: "Reserved_3_c8",
      desc: "Reserved, implementation defined (32 bits over 64)",
      swaccess: "none",
      hwaccess: "none",
      fields: [
        { bits: "31:0" }
      ],
    },
    { name: "Channel_Flags_c8",
      desc: "Defines wheter interrupts or polling is used for communication",
      swaccess: "rw",
      hwaccess: "none",
      fields: [
        { bits: "31:1" },
        { bits: "0",
          name: "intr_enable",
          desc: "If 1 interruts are used, if 0 polling is used"
        }
      ],
    },
    { name: "Length_c8",
      desc: "Lenght of payload + header",
      swaccess: "rw",
      hwaccess: "none",
      fields: [
        { bits: "31:0" }
      ],
    },
    { name: "Message_Header_c8",
      desc: "Defines which commanad the message contains",
      swaccess: "rw",
      hwaccess: "none",
      fields: [
        { bits: "31:28" },
        { bits: "27:18",
          name: "Token",
          desc: "must be same for the msg responses associated to a msg whith the same header"
        },
        { bits: "17:10",
          name: "Protocol_Id",
          desc: "Identifies to which protocol the command belongs to"
        },
        { bits: "9:8",
          name: "Message_Type",
          desc: "can be 0,1,2,3 depending on the kind of msg to be sent"
        },
        { bits: "7:0",
          name: "Message_Id",
          desc: "unique identifier for each command availabe in the protocol pointed by protocol_id"
        }
      ],
    },
    { name: "Message_Payload_1_c8",
      desc: "memory region dedicated to the parameters of the commands and their returns",
      swaccess: "rw",
      hwaccess: "none",
      fields: [
        { bits: "31:0" }
      ],
    },
    { name: "Doorbell_c8",
      desc: "Rapresents the interrupt to be raised towards the platform",
      swaccess: "rw",
      hwaccess: "hro",
      fields: [
        { bits: "31:1",
          name: "Preserve_Mask",
          desc: "These bits must be constant to 0, not used with just one platform and one agent"
        },
        { bits: "0",
          name: "intr",
          desc: "Interrupt bit"
        }
      ],
    },
    { name:  "Completion_Interrupt_c8",
      desc: "Rapresent the interrupt the platform should raise when it finishes to execute the received command",
      swaccess: "rw",
      hwaccess: "hro",
      fields: [
        { bits: "31:1",
          name: "Preserve_Mask",
          desc: "These bits must be constant to 0, not used with just one platform and one agent"
        },
        { bits: "0",
          name: "intr",
          desc: "Interrupt bit"
        }
      ],
    },
    { name: "Reserved_1_c9",
      desc: "Reserved, must be 0",
      swaccess: "rw",
      hwaccess: "none",
      fields: [
        { bits: "31:0" }
      ],
    },
    { name: "Channel_Status_c9",
      desc: "Indicates which entity has access to the Shared Memory",
      swaccess: "rw",
      hwaccess: "none",
      fields: [
        { bits: "31:2" },
        { bits: "1",
          name: "channel_error",
          desc: "Must be 0 in absence of errors"
        },
        { bits: "0",
          name: "channel_free",
          desc: "If 1 the agent own the channel, if 0 the platform own the channel"
        }
      ],
    },
    { name: "Reserved_2_c9",
      desc: "Reserved, implementation defined (32 bits over 64)",
      swaccess: "rw",
      hwaccess: "none",
      fields: [
        { bits: "31:0" }
      ],
    },
    { name: "Reserved_3_c9",
      desc: "Reserved, implementation defined (32 bits over 64)",
      swaccess: "none",
      hwaccess: "none",
      fields: [
        { bits: "31:0" }
      ],
    },
    { name: "Channel_Flags_c9",
      desc: "Defines wheter interrupts or polling is used for communication",
      swaccess: "rw",
      hwaccess: "none",
      fields: [
        { bits: "31:1" },
        { bits: "0",
          name: "intr_enable",
          desc: "If 1 interruts are used, if 0 polling is used"
        }
      ],
    },
    { name: "Length_c9",
      desc: "Lenght of payload + header",
      swaccess: "rw",
      hwaccess: "none",
      fields: [
        { bits: "31:0" }
      ],
    },
    { name: "Message_Header_c9",
      desc: "Defines which commanad the message contains",
      swaccess: "rw",
      hwaccess: "none",
      fields: [
        { bits: "31:28" },
        { bits: "27:18",
          name: "Token",
          desc: "must be same for the msg responses associated to a msg whith the same header"
        },
        { bits: "17:10",
          name: "Protocol_Id",
          desc: "Identifies to which protocol the command belongs to"
        },
        { bits: "9:8",
          name: "Message_Type",
          desc: "can be 0,1,2,3 depending on the kind of msg to be sent"
        },
        { bits: "7:0",
          name: "Message_Id",
          desc: "unique identifier for each command availabe in the protocol pointed by protocol_id"
        }
      ],
    },
    { name: "Message_Payload_1_c9",
      desc: "memory region dedicated to the parameters of the commands and their returns",
      swaccess: "rw",
      hwaccess: "none",
      fields: [
        { bits: "31:0" }
      ],
    },
    { name: "Doorbell_c9",
      desc: "Rapresents the interrupt to be raised towards the platform",
      swaccess: "rw",
      hwaccess: "hro",
      fields: [
        { bits: "31:1",
          name: "Preserve_Mask",
          desc: "These bits must be constant to 0, not used with just one platform and one agent"
        },
        { bits: "0",
          name: "intr",
          desc: "Interrupt bit"
        }
      ],
    },
    { name:  "Completion_Interrupt_c9",
      desc: "Rapresent the interrupt the platform should raise when it finishes to execute the received command",
      swaccess: "rw",
      hwaccess: "hro",
      fields: [
        { bits: "31:1",
          name: "Preserve_Mask",
          desc: "These bits must be constant to 0, not used with just one platform and one agent"
        },
        { bits: "0",
          name: "intr",
          desc: "Interrupt bit"
        }
      ],
    },
    { name: "Reserved_1_c10",
      desc: "Reserved, must be 0",
      swaccess: "rw",
      hwaccess: "none",
      fields: [
        { bits: "31:0" }
      ],
    },
    { name: "Channel_Status_c10",
      desc: "Indicates which entity has access to the Shared Memory",
      swaccess: "rw",
      hwaccess: "none",
      fields: [
        { bits: "31:2" },
        { bits: "1",
          name: "channel_error",
          desc: "Must be 0 in absence of errors"
        },
        { bits: "0",
          name: "channel_free",
          desc: "If 1 the agent own the channel, if 0 the platform own the channel"
        }
      ],
    },
    { name: "Reserved_2_c10",
      desc: "Reserved, implementation defined (32 bits over 64)",
      swaccess: "rw",
      hwaccess: "none",
      fields: [
        { bits: "31:0" }
      ],
    },
    { name: "Reserved_3_c10",
      desc: "Reserved, implementation defined (32 bits over 64)",
      swaccess: "none",
      hwaccess: "none",
      fields: [
        { bits: "31:0" }
      ],
    },
    { name: "Channel_Flags_c10",
      desc: "Defines wheter interrupts or polling is used for communication",
      swaccess: "rw",
      hwaccess: "none",
      fields: [
        { bits: "31:1" },
        { bits: "0",
          name: "intr_enable",
          desc: "If 1 interruts are used, if 0 polling is used"
        }
      ],
    },
    { name: "Length_c10",
      desc: "Lenght of payload + header",
      swaccess: "rw",
      hwaccess: "none",
      fields: [
        { bits: "31:0" }
      ],
    },
    { name: "Message_Header_c10",
      desc: "Defines which commanad the message contains",
      swaccess: "rw",
      hwaccess: "none",
      fields: [
        { bits: "31:28" },
        { bits: "27:18",
          name: "Token",
          desc: "must be same for the msg responses associated to a msg whith the same header"
        },
        { bits: "17:10",
          name: "Protocol_Id",
          desc: "Identifies to which protocol the command belongs to"
        },
        { bits: "9:8",
          name: "Message_Type",
          desc: "can be 0,1,2,3 depending on the kind of msg to be sent"
        },
        { bits: "7:0",
          name: "Message_Id",
          desc: "unique identifier for each command availabe in the protocol pointed by protocol_id"
        }
      ],
    },
    { name: "Message_Payload_1_c10",
      desc: "memory region dedicated to the parameters of the commands and their returns",
      swaccess: "rw",
      hwaccess: "none",
      fields: [
        { bits: "31:0" }
      ],
    },
    { name: "Doorbell_c10",
      desc: "Rapresents the interrupt to be raised towards the platform",
      swaccess: "rw",
      hwaccess: "hro",
      fields: [
        { bits: "31:1",
          name: "Preserve_Mask",
          desc: "These bits must be constant to 0, not used with just one platform and one agent"
        },
        { bits: "0",
          name: "intr",
          desc: "Interrupt bit"
        }
      ],
    },
    { name:  "Completion_Interrupt_c10",
      desc: "Rapresent the interrupt the platform should raise when it finishes to execute the received command",
      swaccess: "rw",
      hwaccess: "hro",
      fields: [
        { bits: "31:1",
          name: "Preserve_Mask",
          desc: "These bits must be constant to 0, not used with just one platform and one agent"
        },
        { bits: "0",
          name: "intr",
          desc: "Interrupt bit"
        }
      ],
    },
    { name: "Reserved_1_c11",
      desc: "Reserved, must be 0",
      swaccess: "rw",
      hwaccess: "none",
      fields: [
        { bits: "31:0" }
      ],
    },
    { name: "Channel_Status_c11",
      desc: "Indicates which entity has access to the Shared Memory",
      swaccess: "rw",
      hwaccess: "none",
      fields: [
        { bits: "31:2" },
        { bits: "1",
          name: "channel_error",
          desc: "Must be 0 in absence of errors"
        },
        { bits: "0",
          name: "channel_free",
          desc: "If 1 the agent own the channel, if 0 the platform own the channel"
        }
      ],
    },
    { name: "Reserved_2_c11",
      desc: "Reserved, implementation defined (32 bits over 64)",
      swaccess: "rw",
      hwaccess: "none",
      fields: [
        { bits: "31:0" }
      ],
    },
    { name: "Reserved_3_c11",
      desc: "Reserved, implementation defined (32 bits over 64)",
      swaccess: "none",
      hwaccess: "none",
      fields: [
        { bits: "31:0" }
      ],
    },
    { name: "Channel_Flags_c11",
      desc: "Defines wheter interrupts or polling is used for communication",
      swaccess: "rw",
      hwaccess: "none",
      fields: [
        { bits: "31:1" },
        { bits: "0",
          name: "intr_enable",
          desc: "If 1 interruts are used, if 0 polling is used"
        }
      ],
    },
    { name: "Length_c11",
      desc: "Lenght of payload + header",
      swaccess: "rw",
      hwaccess: "none",
      fields: [
        { bits: "31:0" }
      ],
    },
    { name: "Message_Header_c11",
      desc: "Defines which commanad the message contains",
      swaccess: "rw",
      hwaccess: "none",
      fields: [
        { bits: "31:28" },
        { bits: "27:18",
          name: "Token",
          desc: "must be same for the msg responses associated to a msg whith the same header"
        },
        { bits: "17:10",
          name: "Protocol_Id",
          desc: "Identifies to which protocol the command belongs to"
        },
        { bits: "9:8",
          name: "Message_Type",
          desc: "can be 0,1,2,3 depending on the kind of msg to be sent"
        },
        { bits: "7:0",
          name: "Message_Id",
          desc: "unique identifier for each command availabe in the protocol pointed by protocol_id"
        }
      ],
    },
    { name: "Message_Payload_1_c11",
      desc: "memory region dedicated to the parameters of the commands and their returns",
      swaccess: "rw",
      hwaccess: "none",
      fields: [
        { bits: "31:0" }
      ],
    },
    { name: "Doorbell_c11",
      desc: "Rapresents the interrupt to be raised towards the platform",
      swaccess: "rw",
      hwaccess: "hro",
      fields: [
        { bits: "31:1",
          name: "Preserve_Mask",
          desc: "These bits must be constant to 0, not used with just one platform and one agent"
        },
        { bits: "0",
          name: "intr",
          desc: "Interrupt bit"
        }
      ],
    },
    { name:  "Completion_Interrupt_c11",
      desc: "Rapresent the interrupt the platform should raise when it finishes to execute the received command",
      swaccess: "rw",
      hwaccess: "hro",
      fields: [
        { bits: "31:1",
          name: "Preserve_Mask",
          desc: "These bits must be constant to 0, not used with just one platform and one agent"
        },
        { bits: "0",
          name: "intr",
          desc: "Interrupt bit"
        }
      ],
    },
    { name: "Reserved_1_c12",
      desc: "Reserved, must be 0",
      swaccess: "rw",
      hwaccess: "none",
      fields: [
        { bits: "31:0" }
      ],
    },
    { name: "Channel_Status_c12",
      desc: "Indicates which entity has access to the Shared Memory",
      swaccess: "rw",
      hwaccess: "none",
      fields: [
        { bits: "31:2" },
        { bits: "1",
          name: "channel_error",
          desc: "Must be 0 in absence of errors"
        },
        { bits: "0",
          name: "channel_free",
          desc: "If 1 the agent own the channel, if 0 the platform own the channel"
        }
      ],
    },
    { name: "Reserved_2_c12",
      desc: "Reserved, implementation defined (32 bits over 64)",
      swaccess: "rw",
      hwaccess: "none",
      fields: [
        { bits: "31:0" }
      ],
    },
    { name: "Reserved_3_c12",
      desc: "Reserved, implementation defined (32 bits over 64)",
      swaccess: "none",
      hwaccess: "none",
      fields: [
        { bits: "31:0" }
      ],
    },
    { name: "Channel_Flags_c12",
      desc: "Defines wheter interrupts or polling is used for communication",
      swaccess: "rw",
      hwaccess: "none",
      fields: [
        { bits: "31:1" },
        { bits: "0",
          name: "intr_enable",
          desc: "If 1 interruts are used, if 0 polling is used"
        }
      ],
    },
    { name: "Length_c12",
      desc: "Lenght of payload + header",
      swaccess: "rw",
      hwaccess: "none",
      fields: [
        { bits: "31:0" }
      ],
    },
    { name: "Message_Header_c12",
      desc: "Defines which commanad the message contains",
      swaccess: "rw",
      hwaccess: "none",
      fields: [
        { bits: "31:28" },
        { bits: "27:18",
          name: "Token",
          desc: "must be same for the msg responses associated to a msg whith the same header"
        },
        { bits: "17:10",
          name: "Protocol_Id",
          desc: "Identifies to which protocol the command belongs to"
        },
        { bits: "9:8",
          name: "Message_Type",
          desc: "can be 0,1,2,3 depending on the kind of msg to be sent"
        },
        { bits: "7:0",
          name: "Message_Id",
          desc: "unique identifier for each command availabe in the protocol pointed by protocol_id"
        }
      ],
    },
    { name: "Message_Payload_1_c12",
      desc: "memory region dedicated to the parameters of the commands and their returns",
      swaccess: "rw",
      hwaccess: "none",
      fields: [
        { bits: "31:0" }
      ],
    },
    { name: "Doorbell_c12",
      desc: "Rapresents the interrupt to be raised towards the platform",
      swaccess: "rw",
      hwaccess: "hro",
      fields: [
        { bits: "31:1",
          name: "Preserve_Mask",
          desc: "These bits must be constant to 0, not used with just one platform and one agent"
        },
        { bits: "0",
          name: "intr",
          desc: "Interrupt bit"
        }
      ],
    },
    { name:  "Completion_Interrupt_c12",
      desc: "Rapresent the interrupt the platform should raise when it finishes to execute the received command",
      swaccess: "rw",
      hwaccess: "hro",
      fields: [
        { bits: "31:1",
          name: "Preserve_Mask",
          desc: "These bits must be constant to 0, not used with just one platform and one agent"
        },
        { bits: "0",
          name: "intr",
          desc: "Interrupt bit"
        }
      ],
    },
    { name: "Reserved_1_c13",
      desc: "Reserved, must be 0",
      swaccess: "rw",
      hwaccess: "none",
      fields: [
        { bits: "31:0" }
      ],
    },
    { name: "Channel_Status_c13",
      desc: "Indicates which entity has access to the Shared Memory",
      swaccess: "rw",
      hwaccess: "none",
      fields: [
        { bits: "31:2" },
        { bits: "1",
          name: "channel_error",
          desc: "Must be 0 in absence of errors"
        },
        { bits: "0",
          name: "channel_free",
          desc: "If 1 the agent own the channel, if 0 the platform own the channel"
        }
      ],
    },
    { name: "Reserved_2_c13",
      desc: "Reserved, implementation defined (32 bits over 64)",
      swaccess: "rw",
      hwaccess: "none",
      fields: [
        { bits: "31:0" }
      ],
    },
    { name: "Reserved_3_c13",
      desc: "Reserved, implementation defined (32 bits over 64)",
      swaccess: "none",
      hwaccess: "none",
      fields: [
        { bits: "31:0" }
      ],
    },
    { name: "Channel_Flags_c13",
      desc: "Defines wheter interrupts or polling is used for communication",
      swaccess: "rw",
      hwaccess: "none",
      fields: [
        { bits: "31:1" },
        { bits: "0",
          name: "intr_enable",
          desc: "If 1 interruts are used, if 0 polling is used"
        }
      ],
    },
    { name: "Length_c13",
      desc: "Lenght of payload + header",
      swaccess: "rw",
      hwaccess: "none",
      fields: [
        { bits: "31:0" }
      ],
    },
    { name: "Message_Header_c13",
      desc: "Defines which commanad the message contains",
      swaccess: "rw",
      hwaccess: "none",
      fields: [
        { bits: "31:28" },
        { bits: "27:18",
          name: "Token",
          desc: "must be same for the msg responses associated to a msg whith the same header"
        },
        { bits: "17:10",
          name: "Protocol_Id",
          desc: "Identifies to which protocol the command belongs to"
        },
        { bits: "9:8",
          name: "Message_Type",
          desc: "can be 0,1,2,3 depending on the kind of msg to be sent"
        },
        { bits: "7:0",
          name: "Message_Id",
          desc: "unique identifier for each command availabe in the protocol pointed by protocol_id"
        }
      ],
    },
    { name: "Message_Payload_1_c13",
      desc: "memory region dedicated to the parameters of the commands and their returns",
      swaccess: "rw",
      hwaccess: "none",
      fields: [
        { bits: "31:0" }
      ],
    },
    { name: "Doorbell_c13",
      desc: "Rapresents the interrupt to be raised towards the platform",
      swaccess: "rw",
      hwaccess: "hro",
      fields: [
        { bits: "31:1",
          name: "Preserve_Mask",
          desc: "These bits must be constant to 0, not used with just one platform and one agent"
        },
        { bits: "0",
          name: "intr",
          desc: "Interrupt bit"
        }
      ],
    },
    { name:  "Completion_Interrupt_c13",
      desc: "Rapresent the interrupt the platform should raise when it finishes to execute the received command",
      swaccess: "rw",
      hwaccess: "hro",
      fields: [
        { bits: "31:1",
          name: "Preserve_Mask",
          desc: "These bits must be constant to 0, not used with just one platform and one agent"
        },
        { bits: "0",
          name: "intr",
          desc: "Interrupt bit"
        }
      ],
    },
    { name: "Reserved_1_c14",
      desc: "Reserved, must be 0",
      swaccess: "rw",
      hwaccess: "none",
      fields: [
        { bits: "31:0" }
      ],
    },
    { name: "Channel_Status_c14",
      desc: "Indicates which entity has access to the Shared Memory",
      swaccess: "rw",
      hwaccess: "none",
      fields: [
        { bits: "31:2" },
        { bits: "1",
          name: "channel_error",
          desc: "Must be 0 in absence of errors"
        },
        { bits: "0",
          name: "channel_free",
          desc: "If 1 the agent own the channel, if 0 the platform own the channel"
        }
      ],
    },
    { name: "Reserved_2_c14",
      desc: "Reserved, implementation defined (32 bits over 64)",
      swaccess: "rw",
      hwaccess: "none",
      fields: [
        { bits: "31:0" }
      ],
    },
    { name: "Reserved_3_c14",
      desc: "Reserved, implementation defined (32 bits over 64)",
      swaccess: "none",
      hwaccess: "none",
      fields: [
        { bits: "31:0" }
      ],
    },
    { name: "Channel_Flags_c14",
      desc: "Defines wheter interrupts or polling is used for communication",
      swaccess: "rw",
      hwaccess: "none",
      fields: [
        { bits: "31:1" },
        { bits: "0",
          name: "intr_enable",
          desc: "If 1 interruts are used, if 0 polling is used"
        }
      ],
    },
    { name: "Length_c14",
      desc: "Lenght of payload + header",
      swaccess: "rw",
      hwaccess: "none",
      fields: [
        { bits: "31:0" }
      ],
    },
    { name: "Message_Header_c14",
      desc: "Defines which commanad the message contains",
      swaccess: "rw",
      hwaccess: "none",
      fields: [
        { bits: "31:28" },
        { bits: "27:18",
          name: "Token",
          desc: "must be same for the msg responses associated to a msg whith the same header"
        },
        { bits: "17:10",
          name: "Protocol_Id",
          desc: "Identifies to which protocol the command belongs to"
        },
        { bits: "9:8",
          name: "Message_Type",
          desc: "can be 0,1,2,3 depending on the kind of msg to be sent"
        },
        { bits: "7:0",
          name: "Message_Id",
          desc: "unique identifier for each command availabe in the protocol pointed by protocol_id"
        }
      ],
    },
    { name: "Message_Payload_1_c14",
      desc: "memory region dedicated to the parameters of the commands and their returns",
      swaccess: "rw",
      hwaccess: "none",
      fields: [
        { bits: "31:0" }
      ],
    },
    { name: "Doorbell_c14",
      desc: "Rapresents the interrupt to be raised towards the platform",
      swaccess: "rw",
      hwaccess: "hro",
      fields: [
        { bits: "31:1",
          name: "Preserve_Mask",
          desc: "These bits must be constant to 0, not used with just one platform and one agent"
        },
        { bits: "0",
          name: "intr",
          desc: "Interrupt bit"
        }
      ],
    },
    { name:  "Completion_Interrupt_c14",
      desc: "Rapresent the interrupt the platform should raise when it finishes to execute the received command",
      swaccess: "rw",
      hwaccess: "hro",
      fields: [
        { bits: "31:1",
          name: "Preserve_Mask",
          desc: "These bits must be constant to 0, not used with just one platform and one agent"
        },
        { bits: "0",
          name: "intr",
          desc: "Interrupt bit"
        }
      ],
    },
    { name: "Reserved_1_c15",
      desc: "Reserved, must be 0",
      swaccess: "rw",
      hwaccess: "none",
      fields: [
        { bits: "31:0" }
      ],
    },
    { name: "Channel_Status_c15",
      desc: "Indicates which entity has access to the Shared Memory",
      swaccess: "rw",
      hwaccess: "none",
      fields: [
        { bits: "31:2" },
        { bits: "1",
          name: "channel_error",
          desc: "Must be 0 in absence of errors"
        },
        { bits: "0",
          name: "channel_free",
          desc: "If 1 the agent own the channel, if 0 the platform own the channel"
        }
      ],
    },
    { name: "Reserved_2_c15",
      desc: "Reserved, implementation defined (32 bits over 64)",
      swaccess: "rw",
      hwaccess: "none",
      fields: [
        { bits: "31:0" }
      ],
    },
    { name: "Reserved_3_c15",
      desc: "Reserved, implementation defined (32 bits over 64)",
      swaccess: "none",
      hwaccess: "none",
      fields: [
        { bits: "31:0" }
      ],
    },
    { name: "Channel_Flags_c15",
      desc: "Defines wheter interrupts or polling is used for communication",
      swaccess: "rw",
      hwaccess: "none",
      fields: [
        { bits: "31:1" },
        { bits: "0",
          name: "intr_enable",
          desc: "If 1 interruts are used, if 0 polling is used"
        }
      ],
    },
    { name: "Length_c15",
      desc: "Lenght of payload + header",
      swaccess: "rw",
      hwaccess: "none",
      fields: [
        { bits: "31:0" }
      ],
    },
    { name: "Message_Header_c15",
      desc: "Defines which commanad the message contains",
      swaccess: "rw",
      hwaccess: "none",
      fields: [
        { bits: "31:28" },
        { bits: "27:18",
          name: "Token",
          desc: "must be same for the msg responses associated to a msg whith the same header"
        },
        { bits: "17:10",
          name: "Protocol_Id",
          desc: "Identifies to which protocol the command belongs to"
        },
        { bits: "9:8",
          name: "Message_Type",
          desc: "can be 0,1,2,3 depending on the kind of msg to be sent"
        },
        { bits: "7:0",
          name: "Message_Id",
          desc: "unique identifier for each command availabe in the protocol pointed by protocol_id"
        }
      ],
    },
    { name: "Message_Payload_1_c15",
      desc: "memory region dedicated to the parameters of the commands and their returns",
      swaccess: "rw",
      hwaccess: "none",
      fields: [
        { bits: "31:0" }
      ],
    },
    { name: "Doorbell_c15",
      desc: "Rapresents the interrupt to be raised towards the platform",
      swaccess: "rw",
      hwaccess: "hro",
      fields: [
        { bits: "31:1",
          name: "Preserve_Mask",
          desc: "These bits must be constant to 0, not used with just one platform and one agent"
        },
        { bits: "0",
          name: "intr",
          desc: "Interrupt bit"
        }
      ],
    },
    { name:  "Completion_Interrupt_c15",
      desc: "Rapresent the interrupt the platform should raise when it finishes to execute the received command",
      swaccess: "rw",
      hwaccess: "hro",
      fields: [
        { bits: "31:1",
          name: "Preserve_Mask",
          desc: "These bits must be constant to 0, not used with just one platform and one agent"
        },
        { bits: "0",
          name: "intr",
          desc: "Interrupt bit"
        }
      ],
    },
    { name: "Reserved_1_c16",
      desc: "Reserved, must be 0",
      swaccess: "rw",
      hwaccess: "none",
      fields: [
        { bits: "31:0" }
      ],
    },
    { name: "Channel_Status_c16",
      desc: "Indicates which entity has access to the Shared Memory",
      swaccess: "rw",
      hwaccess: "none",
      fields: [
        { bits: "31:2" },
        { bits: "1",
          name: "channel_error",
          desc: "Must be 0 in absence of errors"
        },
        { bits: "0",
          name: "channel_free",
          desc: "If 1 the agent own the channel, if 0 the platform own the channel"
        }
      ],
    },
    { name: "Reserved_2_c16",
      desc: "Reserved, implementation defined (32 bits over 64)",
      swaccess: "rw",
      hwaccess: "none",
      fields: [
        { bits: "31:0" }
      ],
    },
    { name: "Reserved_3_c16",
      desc: "Reserved, implementation defined (32 bits over 64)",
      swaccess: "none",
      hwaccess: "none",
      fields: [
        { bits: "31:0" }
      ],
    },
    { name: "Channel_Flags_c16",
      desc: "Defines wheter interrupts or polling is used for communication",
      swaccess: "rw",
      hwaccess: "none",
      fields: [
        { bits: "31:1" },
        { bits: "0",
          name: "intr_enable",
          desc: "If 1 interruts are used, if 0 polling is used"
        }
      ],
    },
    { name: "Length_c16",
      desc: "Lenght of payload + header",
      swaccess: "rw",
      hwaccess: "none",
      fields: [
        { bits: "31:0" }
      ],
    },
    { name: "Message_Header_c16",
      desc: "Defines which commanad the message contains",
      swaccess: "rw",
      hwaccess: "none",
      fields: [
        { bits: "31:28" },
        { bits: "27:18",
          name: "Token",
          desc: "must be same for the msg responses associated to a msg whith the same header"
        },
        { bits: "17:10",
          name: "Protocol_Id",
          desc: "Identifies to which protocol the command belongs to"
        },
        { bits: "9:8",
          name: "Message_Type",
          desc: "can be 0,1,2,3 depending on the kind of msg to be sent"
        },
        { bits: "7:0",
          name: "Message_Id",
          desc: "unique identifier for each command availabe in the protocol pointed by protocol_id"
        }
      ],
    },
    { name: "Message_Payload_1_c16",
      desc: "memory region dedicated to the parameters of the commands and their returns",
      swaccess: "rw",
      hwaccess: "none",
      fields: [
        { bits: "31:0" }
      ],
    },
    { name: "Doorbell_c16",
      desc: "Rapresents the interrupt to be raised towards the platform",
      swaccess: "rw",
      hwaccess: "hro",
      fields: [
        { bits: "31:1",
          name: "Preserve_Mask",
          desc: "These bits must be constant to 0, not used with just one platform and one agent"
        },
        { bits: "0",
          name: "intr",
          desc: "Interrupt bit"
        }
      ],
    },
    { name:  "Completion_Interrupt_c16",
      desc: "Rapresent the interrupt the platform should raise when it finishes to execute the received command",
      swaccess: "rw",
      hwaccess: "hro",
      fields: [
        { bits: "31:1",
          name: "Preserve_Mask",
          desc: "These bits must be constant to 0, not used with just one platform and one agent"
        },
        { bits: "0",
          name: "intr",
          desc: "Interrupt bit"
        }
      ],
    },
    { name: "Reserved_1_c17",
      desc: "Reserved, must be 0",
      swaccess: "rw",
      hwaccess: "none",
      fields: [
        { bits: "31:0" }
      ],
    },
    { name: "Channel_Status_c17",
      desc: "Indicates which entity has access to the Shared Memory",
      swaccess: "rw",
      hwaccess: "none",
      fields: [
        { bits: "31:2" },
        { bits: "1",
          name: "channel_error",
          desc: "Must be 0 in absence of errors"
        },
        { bits: "0",
          name: "channel_free",
          desc: "If 1 the agent own the channel, if 0 the platform own the channel"
        }
      ],
    },
    { name: "Reserved_2_c17",
      desc: "Reserved, implementation defined (32 bits over 64)",
      swaccess: "rw",
      hwaccess: "none",
      fields: [
        { bits: "31:0" }
      ],
    },
    { name: "Reserved_3_c17",
      desc: "Reserved, implementation defined (32 bits over 64)",
      swaccess: "none",
      hwaccess: "none",
      fields: [
        { bits: "31:0" }
      ],
    },
    { name: "Channel_Flags_c17",
      desc: "Defines wheter interrupts or polling is used for communication",
      swaccess: "rw",
      hwaccess: "none",
      fields: [
        { bits: "31:1" },
        { bits: "0",
          name: "intr_enable",
          desc: "If 1 interruts are used, if 0 polling is used"
        }
      ],
    },
    { name: "Length_c17",
      desc: "Lenght of payload + header",
      swaccess: "rw",
      hwaccess: "none",
      fields: [
        { bits: "31:0" }
      ],
    },
    { name: "Message_Header_c17",
      desc: "Defines which commanad the message contains",
      swaccess: "rw",
      hwaccess: "none",
      fields: [
        { bits: "31:28" },
        { bits: "27:18",
          name: "Token",
          desc: "must be same for the msg responses associated to a msg whith the same header"
        },
        { bits: "17:10",
          name: "Protocol_Id",
          desc: "Identifies to which protocol the command belongs to"
        },
        { bits: "9:8",
          name: "Message_Type",
          desc: "can be 0,1,2,3 depending on the kind of msg to be sent"
        },
        { bits: "7:0",
          name: "Message_Id",
          desc: "unique identifier for each command availabe in the protocol pointed by protocol_id"
        }
      ],
    },
    { name: "Message_Payload_1_c17",
      desc: "memory region dedicated to the parameters of the commands and their returns",
      swaccess: "rw",
      hwaccess: "none",
      fields: [
        { bits: "31:0" }
      ],
    },
    { name: "Doorbell_c17",
      desc: "Rapresents the interrupt to be raised towards the platform",
      swaccess: "rw",
      hwaccess: "hro",
      fields: [
        { bits: "31:1",
          name: "Preserve_Mask",
          desc: "These bits must be constant to 0, not used with just one platform and one agent"
        },
        { bits: "0",
          name: "intr",
          desc: "Interrupt bit"
        }
      ],
    },
    { name:  "Completion_Interrupt_c17",
      desc: "Rapresent the interrupt the platform should raise when it finishes to execute the received command",
      swaccess: "rw",
      hwaccess: "hro",
      fields: [
        { bits: "31:1",
          name: "Preserve_Mask",
          desc: "These bits must be constant to 0, not used with just one platform and one agent"
        },
        { bits: "0",
          name: "intr",
          desc: "Interrupt bit"
        }
      ],
    },
    { name: "Reserved_1_c18",
      desc: "Reserved, must be 0",
      swaccess: "rw",
      hwaccess: "none",
      fields: [
        { bits: "31:0" }
      ],
    },
    { name: "Channel_Status_c18",
      desc: "Indicates which entity has access to the Shared Memory",
      swaccess: "rw",
      hwaccess: "none",
      fields: [
        { bits: "31:2" },
        { bits: "1",
          name: "channel_error",
          desc: "Must be 0 in absence of errors"
        },
        { bits: "0",
          name: "channel_free",
          desc: "If 1 the agent own the channel, if 0 the platform own the channel"
        }
      ],
    },
    { name: "Reserved_2_c18",
      desc: "Reserved, implementation defined (32 bits over 64)",
      swaccess: "rw",
      hwaccess: "none",
      fields: [
        { bits: "31:0" }
      ],
    },
    { name: "Reserved_3_c18",
      desc: "Reserved, implementation defined (32 bits over 64)",
      swaccess: "none",
      hwaccess: "none",
      fields: [
        { bits: "31:0" }
      ],
    },
    { name: "Channel_Flags_c18",
      desc: "Defines wheter interrupts or polling is used for communication",
      swaccess: "rw",
      hwaccess: "none",
      fields: [
        { bits: "31:1" },
        { bits: "0",
          name: "intr_enable",
          desc: "If 1 interruts are used, if 0 polling is used"
        }
      ],
    },
    { name: "Length_c18",
      desc: "Lenght of payload + header",
      swaccess: "rw",
      hwaccess: "none",
      fields: [
        { bits: "31:0" }
      ],
    },
    { name: "Message_Header_c18",
      desc: "Defines which commanad the message contains",
      swaccess: "rw",
      hwaccess: "none",
      fields: [
        { bits: "31:28" },
        { bits: "27:18",
          name: "Token",
          desc: "must be same for the msg responses associated to a msg whith the same header"
        },
        { bits: "17:10",
          name: "Protocol_Id",
          desc: "Identifies to which protocol the command belongs to"
        },
        { bits: "9:8",
          name: "Message_Type",
          desc: "can be 0,1,2,3 depending on the kind of msg to be sent"
        },
        { bits: "7:0",
          name: "Message_Id",
          desc: "unique identifier for each command availabe in the protocol pointed by protocol_id"
        }
      ],
    },
    { name: "Message_Payload_1_c18",
      desc: "memory region dedicated to the parameters of the commands and their returns",
      swaccess: "rw",
      hwaccess: "none",
      fields: [
        { bits: "31:0" }
      ],
    },
    { name: "Doorbell_c18",
      desc: "Rapresents the interrupt to be raised towards the platform",
      swaccess: "rw",
      hwaccess: "hro",
      fields: [
        { bits: "31:1",
          name: "Preserve_Mask",
          desc: "These bits must be constant to 0, not used with just one platform and one agent"
        },
        { bits: "0",
          name: "intr",
          desc: "Interrupt bit"
        }
      ],
    },
    { name:  "Completion_Interrupt_c18",
      desc: "Rapresent the interrupt the platform should raise when it finishes to execute the received command",
      swaccess: "rw",
      hwaccess: "hro",
      fields: [
        { bits: "31:1",
          name: "Preserve_Mask",
          desc: "These bits must be constant to 0, not used with just one platform and one agent"
        },
        { bits: "0",
          name: "intr",
          desc: "Interrupt bit"
        }
      ],
    },
    { name: "Reserved_1_c19",
      desc: "Reserved, must be 0",
      swaccess: "rw",
      hwaccess: "none",
      fields: [
        { bits: "31:0" }
      ],
    },
    { name: "Channel_Status_c19",
      desc: "Indicates which entity has access to the Shared Memory",
      swaccess: "rw",
      hwaccess: "none",
      fields: [
        { bits: "31:2" },
        { bits: "1",
          name: "channel_error",
          desc: "Must be 0 in absence of errors"
        },
        { bits: "0",
          name: "channel_free",
          desc: "If 1 the agent own the channel, if 0 the platform own the channel"
        }
      ],
    },
    { name: "Reserved_2_c19",
      desc: "Reserved, implementation defined (32 bits over 64)",
      swaccess: "rw",
      hwaccess: "none",
      fields: [
        { bits: "31:0" }
      ],
    },
    { name: "Reserved_3_c19",
      desc: "Reserved, implementation defined (32 bits over 64)",
      swaccess: "none",
      hwaccess: "none",
      fields: [
        { bits: "31:0" }
      ],
    },
    { name: "Channel_Flags_c19",
      desc: "Defines wheter interrupts or polling is used for communication",
      swaccess: "rw",
      hwaccess: "none",
      fields: [
        { bits: "31:1" },
        { bits: "0",
          name: "intr_enable",
          desc: "If 1 interruts are used, if 0 polling is used"
        }
      ],
    },
    { name: "Length_c19",
      desc: "Lenght of payload + header",
      swaccess: "rw",
      hwaccess: "none",
      fields: [
        { bits: "31:0" }
      ],
    },
    { name: "Message_Header_c19",
      desc: "Defines which commanad the message contains",
      swaccess: "rw",
      hwaccess: "none",
      fields: [
        { bits: "31:28" },
        { bits: "27:18",
          name: "Token",
          desc: "must be same for the msg responses associated to a msg whith the same header"
        },
        { bits: "17:10",
          name: "Protocol_Id",
          desc: "Identifies to which protocol the command belongs to"
        },
        { bits: "9:8",
          name: "Message_Type",
          desc: "can be 0,1,2,3 depending on the kind of msg to be sent"
        },
        { bits: "7:0",
          name: "Message_Id",
          desc: "unique identifier for each command availabe in the protocol pointed by protocol_id"
        }
      ],
    },
    { name: "Message_Payload_1_c19",
      desc: "memory region dedicated to the parameters of the commands and their returns",
      swaccess: "rw",
      hwaccess: "none",
      fields: [
        { bits: "31:0" }
      ],
    },
    { name: "Doorbell_c19",
      desc: "Rapresents the interrupt to be raised towards the platform",
      swaccess: "rw",
      hwaccess: "hro",
      fields: [
        { bits: "31:1",
          name: "Preserve_Mask",
          desc: "These bits must be constant to 0, not used with just one platform and one agent"
        },
        { bits: "0",
          name: "intr",
          desc: "Interrupt bit"
        }
      ],
    },
    { name:  "Completion_Interrupt_c19",
      desc: "Rapresent the interrupt the platform should raise when it finishes to execute the received command",
      swaccess: "rw",
      hwaccess: "hro",
      fields: [
        { bits: "31:1",
          name: "Preserve_Mask",
          desc: "These bits must be constant to 0, not used with just one platform and one agent"
        },
        { bits: "0",
          name: "intr",
          desc: "Interrupt bit"
        }
      ],
    },
    { name: "Reserved_1_c20",
      desc: "Reserved, must be 0",
      swaccess: "rw",
      hwaccess: "none",
      fields: [
        { bits: "31:0" }
      ],
    },
    { name: "Channel_Status_c20",
      desc: "Indicates which entity has access to the Shared Memory",
      swaccess: "rw",
      hwaccess: "none",
      fields: [
        { bits: "31:2" },
        { bits: "1",
          name: "channel_error",
          desc: "Must be 0 in absence of errors"
        },
        { bits: "0",
          name: "channel_free",
          desc: "If 1 the agent own the channel, if 0 the platform own the channel"
        }
      ],
    },
    { name: "Reserved_2_c20",
      desc: "Reserved, implementation defined (32 bits over 64)",
      swaccess: "rw",
      hwaccess: "none",
      fields: [
        { bits: "31:0" }
      ],
    },
    { name: "Reserved_3_c20",
      desc: "Reserved, implementation defined (32 bits over 64)",
      swaccess: "none",
      hwaccess: "none",
      fields: [
        { bits: "31:0" }
      ],
    },
    { name: "Channel_Flags_c20",
      desc: "Defines wheter interrupts or polling is used for communication",
      swaccess: "rw",
      hwaccess: "none",
      fields: [
        { bits: "31:1" },
        { bits: "0",
          name: "intr_enable",
          desc: "If 1 interruts are used, if 0 polling is used"
        }
      ],
    },
    { name: "Length_c20",
      desc: "Lenght of payload + header",
      swaccess: "rw",
      hwaccess: "none",
      fields: [
        { bits: "31:0" }
      ],
    },
    { name: "Message_Header_c20",
      desc: "Defines which commanad the message contains",
      swaccess: "rw",
      hwaccess: "none",
      fields: [
        { bits: "31:28" },
        { bits: "27:18",
          name: "Token",
          desc: "must be same for the msg responses associated to a msg whith the same header"
        },
        { bits: "17:10",
          name: "Protocol_Id",
          desc: "Identifies to which protocol the command belongs to"
        },
        { bits: "9:8",
          name: "Message_Type",
          desc: "can be 0,1,2,3 depending on the kind of msg to be sent"
        },
        { bits: "7:0",
          name: "Message_Id",
          desc: "unique identifier for each command availabe in the protocol pointed by protocol_id"
        }
      ],
    },
    { name: "Message_Payload_1_c20",
      desc: "memory region dedicated to the parameters of the commands and their returns",
      swaccess: "rw",
      hwaccess: "none",
      fields: [
        { bits: "31:0" }
      ],
    },
    { name: "Doorbell_c20",
      desc: "Rapresents the interrupt to be raised towards the platform",
      swaccess: "rw",
      hwaccess: "hro",
      fields: [
        { bits: "31:1",
          name: "Preserve_Mask",
          desc: "These bits must be constant to 0, not used with just one platform and one agent"
        },
        { bits: "0",
          name: "intr",
          desc: "Interrupt bit"
        }
      ],
    },
    { name:  "Completion_Interrupt_c20",
      desc: "Rapresent the interrupt the platform should raise when it finishes to execute the received command",
      swaccess: "rw",
      hwaccess: "hro",
      fields: [
        { bits: "31:1",
          name: "Preserve_Mask",
          desc: "These bits must be constant to 0, not used with just one platform and one agent"
        },
        { bits: "0",
          name: "intr",
          desc: "Interrupt bit"
        }
      ],
    },
    { name: "Reserved_1_c21",
      desc: "Reserved, must be 0",
      swaccess: "rw",
      hwaccess: "none",
      fields: [
        { bits: "31:0" }
      ],
    },
    { name: "Channel_Status_c21",
      desc: "Indicates which entity has access to the Shared Memory",
      swaccess: "rw",
      hwaccess: "none",
      fields: [
        { bits: "31:2" },
        { bits: "1",
          name: "channel_error",
          desc: "Must be 0 in absence of errors"
        },
        { bits: "0",
          name: "channel_free",
          desc: "If 1 the agent own the channel, if 0 the platform own the channel"
        }
      ],
    },
    { name: "Reserved_2_c21",
      desc: "Reserved, implementation defined (32 bits over 64)",
      swaccess: "rw",
      hwaccess: "none",
      fields: [
        { bits: "31:0" }
      ],
    },
    { name: "Reserved_3_c21",
      desc: "Reserved, implementation defined (32 bits over 64)",
      swaccess: "none",
      hwaccess: "none",
      fields: [
        { bits: "31:0" }
      ],
    },
    { name: "Channel_Flags_c21",
      desc: "Defines wheter interrupts or polling is used for communication",
      swaccess: "rw",
      hwaccess: "none",
      fields: [
        { bits: "31:1" },
        { bits: "0",
          name: "intr_enable",
          desc: "If 1 interruts are used, if 0 polling is used"
        }
      ],
    },
    { name: "Length_c21",
      desc: "Lenght of payload + header",
      swaccess: "rw",
      hwaccess: "none",
      fields: [
        { bits: "31:0" }
      ],
    },
    { name: "Message_Header_c21",
      desc: "Defines which commanad the message contains",
      swaccess: "rw",
      hwaccess: "none",
      fields: [
        { bits: "31:28" },
        { bits: "27:18",
          name: "Token",
          desc: "must be same for the msg responses associated to a msg whith the same header"
        },
        { bits: "17:10",
          name: "Protocol_Id",
          desc: "Identifies to which protocol the command belongs to"
        },
        { bits: "9:8",
          name: "Message_Type",
          desc: "can be 0,1,2,3 depending on the kind of msg to be sent"
        },
        { bits: "7:0",
          name: "Message_Id",
          desc: "unique identifier for each command availabe in the protocol pointed by protocol_id"
        }
      ],
    },
    { name: "Message_Payload_1_c21",
      desc: "memory region dedicated to the parameters of the commands and their returns",
      swaccess: "rw",
      hwaccess: "none",
      fields: [
        { bits: "31:0" }
      ],
    },
    { name: "Doorbell_c21",
      desc: "Rapresents the interrupt to be raised towards the platform",
      swaccess: "rw",
      hwaccess: "hro",
      fields: [
        { bits: "31:1",
          name: "Preserve_Mask",
          desc: "These bits must be constant to 0, not used with just one platform and one agent"
        },
        { bits: "0",
          name: "intr",
          desc: "Interrupt bit"
        }
      ],
    },
    { name:  "Completion_Interrupt_c21",
      desc: "Rapresent the interrupt the platform should raise when it finishes to execute the received command",
      swaccess: "rw",
      hwaccess: "hro",
      fields: [
        { bits: "31:1",
          name: "Preserve_Mask",
          desc: "These bits must be constant to 0, not used with just one platform and one agent"
        },
        { bits: "0",
          name: "intr",
          desc: "Interrupt bit"
        }
      ],
    },
    { name: "Reserved_1_c22",
      desc: "Reserved, must be 0",
      swaccess: "rw",
      hwaccess: "none",
      fields: [
        { bits: "31:0" }
      ],
    },
    { name: "Channel_Status_c22",
      desc: "Indicates which entity has access to the Shared Memory",
      swaccess: "rw",
      hwaccess: "none",
      fields: [
        { bits: "31:2" },
        { bits: "1",
          name: "channel_error",
          desc: "Must be 0 in absence of errors"
        },
        { bits: "0",
          name: "channel_free",
          desc: "If 1 the agent own the channel, if 0 the platform own the channel"
        }
      ],
    },
    { name: "Reserved_2_c22",
      desc: "Reserved, implementation defined (32 bits over 64)",
      swaccess: "rw",
      hwaccess: "none",
      fields: [
        { bits: "31:0" }
      ],
    },
    { name: "Reserved_3_c22",
      desc: "Reserved, implementation defined (32 bits over 64)",
      swaccess: "none",
      hwaccess: "none",
      fields: [
        { bits: "31:0" }
      ],
    },
    { name: "Channel_Flags_c22",
      desc: "Defines wheter interrupts or polling is used for communication",
      swaccess: "rw",
      hwaccess: "none",
      fields: [
        { bits: "31:1" },
        { bits: "0",
          name: "intr_enable",
          desc: "If 1 interruts are used, if 0 polling is used"
        }
      ],
    },
    { name: "Length_c22",
      desc: "Lenght of payload + header",
      swaccess: "rw",
      hwaccess: "none",
      fields: [
        { bits: "31:0" }
      ],
    },
    { name: "Message_Header_c22",
      desc: "Defines which commanad the message contains",
      swaccess: "rw",
      hwaccess: "none",
      fields: [
        { bits: "31:28" },
        { bits: "27:18",
          name: "Token",
          desc: "must be same for the msg responses associated to a msg whith the same header"
        },
        { bits: "17:10",
          name: "Protocol_Id",
          desc: "Identifies to which protocol the command belongs to"
        },
        { bits: "9:8",
          name: "Message_Type",
          desc: "can be 0,1,2,3 depending on the kind of msg to be sent"
        },
        { bits: "7:0",
          name: "Message_Id",
          desc: "unique identifier for each command availabe in the protocol pointed by protocol_id"
        }
      ],
    },
    { name: "Message_Payload_1_c22",
      desc: "memory region dedicated to the parameters of the commands and their returns",
      swaccess: "rw",
      hwaccess: "none",
      fields: [
        { bits: "31:0" }
      ],
    },
    { name: "Doorbell_c22",
      desc: "Rapresents the interrupt to be raised towards the platform",
      swaccess: "rw",
      hwaccess: "hro",
      fields: [
        { bits: "31:1",
          name: "Preserve_Mask",
          desc: "These bits must be constant to 0, not used with just one platform and one agent"
        },
        { bits: "0",
          name: "intr",
          desc: "Interrupt bit"
        }
      ],
    },
    { name:  "Completion_Interrupt_c22",
      desc: "Rapresent the interrupt the platform should raise when it finishes to execute the received command",
      swaccess: "rw",
      hwaccess: "hro",
      fields: [
        { bits: "31:1",
          name: "Preserve_Mask",
          desc: "These bits must be constant to 0, not used with just one platform and one agent"
        },
        { bits: "0",
          name: "intr",
          desc: "Interrupt bit"
        }
      ],
    },
    { name: "Reserved_1_c23",
      desc: "Reserved, must be 0",
      swaccess: "rw",
      hwaccess: "none",
      fields: [
        { bits: "31:0" }
      ],
    },
    { name: "Channel_Status_c23",
      desc: "Indicates which entity has access to the Shared Memory",
      swaccess: "rw",
      hwaccess: "none",
      fields: [
        { bits: "31:2" },
        { bits: "1",
          name: "channel_error",
          desc: "Must be 0 in absence of errors"
        },
        { bits: "0",
          name: "channel_free",
          desc: "If 1 the agent own the channel, if 0 the platform own the channel"
        }
      ],
    },
    { name: "Reserved_2_c23",
      desc: "Reserved, implementation defined (32 bits over 64)",
      swaccess: "rw",
      hwaccess: "none",
      fields: [
        { bits: "31:0" }
      ],
    },
    { name: "Reserved_3_c23",
      desc: "Reserved, implementation defined (32 bits over 64)",
      swaccess: "none",
      hwaccess: "none",
      fields: [
        { bits: "31:0" }
      ],
    },
    { name: "Channel_Flags_c23",
      desc: "Defines wheter interrupts or polling is used for communication",
      swaccess: "rw",
      hwaccess: "none",
      fields: [
        { bits: "31:1" },
        { bits: "0",
          name: "intr_enable",
          desc: "If 1 interruts are used, if 0 polling is used"
        }
      ],
    },
    { name: "Length_c23",
      desc: "Lenght of payload + header",
      swaccess: "rw",
      hwaccess: "none",
      fields: [
        { bits: "31:0" }
      ],
    },
    { name: "Message_Header_c23",
      desc: "Defines which commanad the message contains",
      swaccess: "rw",
      hwaccess: "none",
      fields: [
        { bits: "31:28" },
        { bits: "27:18",
          name: "Token",
          desc: "must be same for the msg responses associated to a msg whith the same header"
        },
        { bits: "17:10",
          name: "Protocol_Id",
          desc: "Identifies to which protocol the command belongs to"
        },
        { bits: "9:8",
          name: "Message_Type",
          desc: "can be 0,1,2,3 depending on the kind of msg to be sent"
        },
        { bits: "7:0",
          name: "Message_Id",
          desc: "unique identifier for each command availabe in the protocol pointed by protocol_id"
        }
      ],
    },
    { name: "Message_Payload_1_c23",
      desc: "memory region dedicated to the parameters of the commands and their returns",
      swaccess: "rw",
      hwaccess: "none",
      fields: [
        { bits: "31:0" }
      ],
    },
    { name: "Doorbell_c23",
      desc: "Rapresents the interrupt to be raised towards the platform",
      swaccess: "rw",
      hwaccess: "hro",
      fields: [
        { bits: "31:1",
          name: "Preserve_Mask",
          desc: "These bits must be constant to 0, not used with just one platform and one agent"
        },
        { bits: "0",
          name: "intr",
          desc: "Interrupt bit"
        }
      ],
    },
    { name:  "Completion_Interrupt_c23",
      desc: "Rapresent the interrupt the platform should raise when it finishes to execute the received command",
      swaccess: "rw",
      hwaccess: "hro",
      fields: [
        { bits: "31:1",
          name: "Preserve_Mask",
          desc: "These bits must be constant to 0, not used with just one platform and one agent"
        },
        { bits: "0",
          name: "intr",
          desc: "Interrupt bit"
        }
      ],
    },
    { name: "Reserved_1_c24",
      desc: "Reserved, must be 0",
      swaccess: "rw",
      hwaccess: "none",
      fields: [
        { bits: "31:0" }
      ],
    },
    { name: "Channel_Status_c24",
      desc: "Indicates which entity has access to the Shared Memory",
      swaccess: "rw",
      hwaccess: "none",
      fields: [
        { bits: "31:2" },
        { bits: "1",
          name: "channel_error",
          desc: "Must be 0 in absence of errors"
        },
        { bits: "0",
          name: "channel_free",
          desc: "If 1 the agent own the channel, if 0 the platform own the channel"
        }
      ],
    },
    { name: "Reserved_2_c24",
      desc: "Reserved, implementation defined (32 bits over 64)",
      swaccess: "rw",
      hwaccess: "none",
      fields: [
        { bits: "31:0" }
      ],
    },
    { name: "Reserved_3_c24",
      desc: "Reserved, implementation defined (32 bits over 64)",
      swaccess: "none",
      hwaccess: "none",
      fields: [
        { bits: "31:0" }
      ],
    },
    { name: "Channel_Flags_c24",
      desc: "Defines wheter interrupts or polling is used for communication",
      swaccess: "rw",
      hwaccess: "none",
      fields: [
        { bits: "31:1" },
        { bits: "0",
          name: "intr_enable",
          desc: "If 1 interruts are used, if 0 polling is used"
        }
      ],
    },
    { name: "Length_c24",
      desc: "Lenght of payload + header",
      swaccess: "rw",
      hwaccess: "none",
      fields: [
        { bits: "31:0" }
      ],
    },
    { name: "Message_Header_c24",
      desc: "Defines which commanad the message contains",
      swaccess: "rw",
      hwaccess: "none",
      fields: [
        { bits: "31:28" },
        { bits: "27:18",
          name: "Token",
          desc: "must be same for the msg responses associated to a msg whith the same header"
        },
        { bits: "17:10",
          name: "Protocol_Id",
          desc: "Identifies to which protocol the command belongs to"
        },
        { bits: "9:8",
          name: "Message_Type",
          desc: "can be 0,1,2,3 depending on the kind of msg to be sent"
        },
        { bits: "7:0",
          name: "Message_Id",
          desc: "unique identifier for each command availabe in the protocol pointed by protocol_id"
        }
      ],
    },
    { name: "Message_Payload_1_c24",
      desc: "memory region dedicated to the parameters of the commands and their returns",
      swaccess: "rw",
      hwaccess: "none",
      fields: [
        { bits: "31:0" }
      ],
    },
    { name: "Doorbell_c24",
      desc: "Rapresents the interrupt to be raised towards the platform",
      swaccess: "rw",
      hwaccess: "hro",
      fields: [
        { bits: "31:1",
          name: "Preserve_Mask",
          desc: "These bits must be constant to 0, not used with just one platform and one agent"
        },
        { bits: "0",
          name: "intr",
          desc: "Interrupt bit"
        }
      ],
    },
    { name:  "Completion_Interrupt_c24",
      desc: "Rapresent the interrupt the platform should raise when it finishes to execute the received command",
      swaccess: "rw",
      hwaccess: "hro",
      fields: [
        { bits: "31:1",
          name: "Preserve_Mask",
          desc: "These bits must be constant to 0, not used with just one platform and one agent"
        },
        { bits: "0",
          name: "intr",
          desc: "Interrupt bit"
        }
      ],
    },
    { name: "Reserved_1_c25",
      desc: "Reserved, must be 0",
      swaccess: "rw",
      hwaccess: "none",
      fields: [
        { bits: "31:0" }
      ],
    },
    { name: "Channel_Status_c25",
      desc: "Indicates which entity has access to the Shared Memory",
      swaccess: "rw",
      hwaccess: "none",
      fields: [
        { bits: "31:2" },
        { bits: "1",
          name: "channel_error",
          desc: "Must be 0 in absence of errors"
        },
        { bits: "0",
          name: "channel_free",
          desc: "If 1 the agent own the channel, if 0 the platform own the channel"
        }
      ],
    },
    { name: "Reserved_2_c25",
      desc: "Reserved, implementation defined (32 bits over 64)",
      swaccess: "rw",
      hwaccess: "none",
      fields: [
        { bits: "31:0" }
      ],
    },
    { name: "Reserved_3_c25",
      desc: "Reserved, implementation defined (32 bits over 64)",
      swaccess: "none",
      hwaccess: "none",
      fields: [
        { bits: "31:0" }
      ],
    },
    { name: "Channel_Flags_c25",
      desc: "Defines wheter interrupts or polling is used for communication",
      swaccess: "rw",
      hwaccess: "none",
      fields: [
        { bits: "31:1" },
        { bits: "0",
          name: "intr_enable",
          desc: "If 1 interruts are used, if 0 polling is used"
        }
      ],
    },
    { name: "Length_c25",
      desc: "Lenght of payload + header",
      swaccess: "rw",
      hwaccess: "none",
      fields: [
        { bits: "31:0" }
      ],
    },
    { name: "Message_Header_c25",
      desc: "Defines which commanad the message contains",
      swaccess: "rw",
      hwaccess: "none",
      fields: [
        { bits: "31:28" },
        { bits: "27:18",
          name: "Token",
          desc: "must be same for the msg responses associated to a msg whith the same header"
        },
        { bits: "17:10",
          name: "Protocol_Id",
          desc: "Identifies to which protocol the command belongs to"
        },
        { bits: "9:8",
          name: "Message_Type",
          desc: "can be 0,1,2,3 depending on the kind of msg to be sent"
        },
        { bits: "7:0",
          name: "Message_Id",
          desc: "unique identifier for each command availabe in the protocol pointed by protocol_id"
        }
      ],
    },
    { name: "Message_Payload_1_c25",
      desc: "memory region dedicated to the parameters of the commands and their returns",
      swaccess: "rw",
      hwaccess: "none",
      fields: [
        { bits: "31:0" }
      ],
    },
    { name: "Doorbell_c25",
      desc: "Rapresents the interrupt to be raised towards the platform",
      swaccess: "rw",
      hwaccess: "hro",
      fields: [
        { bits: "31:1",
          name: "Preserve_Mask",
          desc: "These bits must be constant to 0, not used with just one platform and one agent"
        },
        { bits: "0",
          name: "intr",
          desc: "Interrupt bit"
        }
      ],
    },
    { name:  "Completion_Interrupt_c25",
      desc: "Rapresent the interrupt the platform should raise when it finishes to execute the received command",
      swaccess: "rw",
      hwaccess: "hro",
      fields: [
        { bits: "31:1",
          name: "Preserve_Mask",
          desc: "These bits must be constant to 0, not used with just one platform and one agent"
        },
        { bits: "0",
          name: "intr",
          desc: "Interrupt bit"
        }
      ],
    },
    { name: "Reserved_1_c26",
      desc: "Reserved, must be 0",
      swaccess: "rw",
      hwaccess: "none",
      fields: [
        { bits: "31:0" }
      ],
    },
    { name: "Channel_Status_c26",
      desc: "Indicates which entity has access to the Shared Memory",
      swaccess: "rw",
      hwaccess: "none",
      fields: [
        { bits: "31:2" },
        { bits: "1",
          name: "channel_error",
          desc: "Must be 0 in absence of errors"
        },
        { bits: "0",
          name: "channel_free",
          desc: "If 1 the agent own the channel, if 0 the platform own the channel"
        }
      ],
    },
    { name: "Reserved_2_c26",
      desc: "Reserved, implementation defined (32 bits over 64)",
      swaccess: "rw",
      hwaccess: "none",
      fields: [
        { bits: "31:0" }
      ],
    },
    { name: "Reserved_3_c26",
      desc: "Reserved, implementation defined (32 bits over 64)",
      swaccess: "none",
      hwaccess: "none",
      fields: [
        { bits: "31:0" }
      ],
    },
    { name: "Channel_Flags_c26",
      desc: "Defines wheter interrupts or polling is used for communication",
      swaccess: "rw",
      hwaccess: "none",
      fields: [
        { bits: "31:1" },
        { bits: "0",
          name: "intr_enable",
          desc: "If 1 interruts are used, if 0 polling is used"
        }
      ],
    },
    { name: "Length_c26",
      desc: "Lenght of payload + header",
      swaccess: "rw",
      hwaccess: "none",
      fields: [
        { bits: "31:0" }
      ],
    },
    { name: "Message_Header_c26",
      desc: "Defines which commanad the message contains",
      swaccess: "rw",
      hwaccess: "none",
      fields: [
        { bits: "31:28" },
        { bits: "27:18",
          name: "Token",
          desc: "must be same for the msg responses associated to a msg whith the same header"
        },
        { bits: "17:10",
          name: "Protocol_Id",
          desc: "Identifies to which protocol the command belongs to"
        },
        { bits: "9:8",
          name: "Message_Type",
          desc: "can be 0,1,2,3 depending on the kind of msg to be sent"
        },
        { bits: "7:0",
          name: "Message_Id",
          desc: "unique identifier for each command availabe in the protocol pointed by protocol_id"
        }
      ],
    },
    { name: "Message_Payload_1_c26",
      desc: "memory region dedicated to the parameters of the commands and their returns",
      swaccess: "rw",
      hwaccess: "none",
      fields: [
        { bits: "31:0" }
      ],
    },
    { name: "Doorbell_c26",
      desc: "Rapresents the interrupt to be raised towards the platform",
      swaccess: "rw",
      hwaccess: "hro",
      fields: [
        { bits: "31:1",
          name: "Preserve_Mask",
          desc: "These bits must be constant to 0, not used with just one platform and one agent"
        },
        { bits: "0",
          name: "intr",
          desc: "Interrupt bit"
        }
      ],
    },
    { name:  "Completion_Interrupt_c26",
      desc: "Rapresent the interrupt the platform should raise when it finishes to execute the received command",
      swaccess: "rw",
      hwaccess: "hro",
      fields: [
        { bits: "31:1",
          name: "Preserve_Mask",
          desc: "These bits must be constant to 0, not used with just one platform and one agent"
        },
        { bits: "0",
          name: "intr",
          desc: "Interrupt bit"
        }
      ],
    },
    { name: "Reserved_1_c27",
      desc: "Reserved, must be 0",
      swaccess: "rw",
      hwaccess: "none",
      fields: [
        { bits: "31:0" }
      ],
    },
    { name: "Channel_Status_c27",
      desc: "Indicates which entity has access to the Shared Memory",
      swaccess: "rw",
      hwaccess: "none",
      fields: [
        { bits: "31:2" },
        { bits: "1",
          name: "channel_error",
          desc: "Must be 0 in absence of errors"
        },
        { bits: "0",
          name: "channel_free",
          desc: "If 1 the agent own the channel, if 0 the platform own the channel"
        }
      ],
    },
    { name: "Reserved_2_c27",
      desc: "Reserved, implementation defined (32 bits over 64)",
      swaccess: "rw",
      hwaccess: "none",
      fields: [
        { bits: "31:0" }
      ],
    },
    { name: "Reserved_3_c27",
      desc: "Reserved, implementation defined (32 bits over 64)",
      swaccess: "none",
      hwaccess: "none",
      fields: [
        { bits: "31:0" }
      ],
    },
    { name: "Channel_Flags_c27",
      desc: "Defines wheter interrupts or polling is used for communication",
      swaccess: "rw",
      hwaccess: "none",
      fields: [
        { bits: "31:1" },
        { bits: "0",
          name: "intr_enable",
          desc: "If 1 interruts are used, if 0 polling is used"
        }
      ],
    },
    { name: "Length_c27",
      desc: "Lenght of payload + header",
      swaccess: "rw",
      hwaccess: "none",
      fields: [
        { bits: "31:0" }
      ],
    },
    { name: "Message_Header_c27",
      desc: "Defines which commanad the message contains",
      swaccess: "rw",
      hwaccess: "none",
      fields: [
        { bits: "31:28" },
        { bits: "27:18",
          name: "Token",
          desc: "must be same for the msg responses associated to a msg whith the same header"
        },
        { bits: "17:10",
          name: "Protocol_Id",
          desc: "Identifies to which protocol the command belongs to"
        },
        { bits: "9:8",
          name: "Message_Type",
          desc: "can be 0,1,2,3 depending on the kind of msg to be sent"
        },
        { bits: "7:0",
          name: "Message_Id",
          desc: "unique identifier for each command availabe in the protocol pointed by protocol_id"
        }
      ],
    },
    { name: "Message_Payload_1_c27",
      desc: "memory region dedicated to the parameters of the commands and their returns",
      swaccess: "rw",
      hwaccess: "none",
      fields: [
        { bits: "31:0" }
      ],
    },
    { name: "Doorbell_c27",
      desc: "Rapresents the interrupt to be raised towards the platform",
      swaccess: "rw",
      hwaccess: "hro",
      fields: [
        { bits: "31:1",
          name: "Preserve_Mask",
          desc: "These bits must be constant to 0, not used with just one platform and one agent"
        },
        { bits: "0",
          name: "intr",
          desc: "Interrupt bit"
        }
      ],
    },
    { name:  "Completion_Interrupt_c27",
      desc: "Rapresent the interrupt the platform should raise when it finishes to execute the received command",
      swaccess: "rw",
      hwaccess: "hro",
      fields: [
        { bits: "31:1",
          name: "Preserve_Mask",
          desc: "These bits must be constant to 0, not used with just one platform and one agent"
        },
        { bits: "0",
          name: "intr",
          desc: "Interrupt bit"
        }
      ],
    },
    { name: "Reserved_1_c28",
      desc: "Reserved, must be 0",
      swaccess: "rw",
      hwaccess: "none",
      fields: [
        { bits: "31:0" }
      ],
    },
    { name: "Channel_Status_c28",
      desc: "Indicates which entity has access to the Shared Memory",
      swaccess: "rw",
      hwaccess: "none",
      fields: [
        { bits: "31:2" },
        { bits: "1",
          name: "channel_error",
          desc: "Must be 0 in absence of errors"
        },
        { bits: "0",
          name: "channel_free",
          desc: "If 1 the agent own the channel, if 0 the platform own the channel"
        }
      ],
    },
    { name: "Reserved_2_c28",
      desc: "Reserved, implementation defined (32 bits over 64)",
      swaccess: "rw",
      hwaccess: "none",
      fields: [
        { bits: "31:0" }
      ],
    },
    { name: "Reserved_3_c28",
      desc: "Reserved, implementation defined (32 bits over 64)",
      swaccess: "none",
      hwaccess: "none",
      fields: [
        { bits: "31:0" }
      ],
    },
    { name: "Channel_Flags_c28",
      desc: "Defines wheter interrupts or polling is used for communication",
      swaccess: "rw",
      hwaccess: "none",
      fields: [
        { bits: "31:1" },
        { bits: "0",
          name: "intr_enable",
          desc: "If 1 interruts are used, if 0 polling is used"
        }
      ],
    },
    { name: "Length_c28",
      desc: "Lenght of payload + header",
      swaccess: "rw",
      hwaccess: "none",
      fields: [
        { bits: "31:0" }
      ],
    },
    { name: "Message_Header_c28",
      desc: "Defines which commanad the message contains",
      swaccess: "rw",
      hwaccess: "none",
      fields: [
        { bits: "31:28" },
        { bits: "27:18",
          name: "Token",
          desc: "must be same for the msg responses associated to a msg whith the same header"
        },
        { bits: "17:10",
          name: "Protocol_Id",
          desc: "Identifies to which protocol the command belongs to"
        },
        { bits: "9:8",
          name: "Message_Type",
          desc: "can be 0,1,2,3 depending on the kind of msg to be sent"
        },
        { bits: "7:0",
          name: "Message_Id",
          desc: "unique identifier for each command availabe in the protocol pointed by protocol_id"
        }
      ],
    },
    { name: "Message_Payload_1_c28",
      desc: "memory region dedicated to the parameters of the commands and their returns",
      swaccess: "rw",
      hwaccess: "none",
      fields: [
        { bits: "31:0" }
      ],
    },
    { name: "Doorbell_c28",
      desc: "Rapresents the interrupt to be raised towards the platform",
      swaccess: "rw",
      hwaccess: "hro",
      fields: [
        { bits: "31:1",
          name: "Preserve_Mask",
          desc: "These bits must be constant to 0, not used with just one platform and one agent"
        },
        { bits: "0",
          name: "intr",
          desc: "Interrupt bit"
        }
      ],
    },
    { name:  "Completion_Interrupt_c28",
      desc: "Rapresent the interrupt the platform should raise when it finishes to execute the received command",
      swaccess: "rw",
      hwaccess: "hro",
      fields: [
        { bits: "31:1",
          name: "Preserve_Mask",
          desc: "These bits must be constant to 0, not used with just one platform and one agent"
        },
        { bits: "0",
          name: "intr",
          desc: "Interrupt bit"
        }
      ],
    },
    { name: "Reserved_1_c29",
      desc: "Reserved, must be 0",
      swaccess: "rw",
      hwaccess: "none",
      fields: [
        { bits: "31:0" }
      ],
    },
    { name: "Channel_Status_c29",
      desc: "Indicates which entity has access to the Shared Memory",
      swaccess: "rw",
      hwaccess: "none",
      fields: [
        { bits: "31:2" },
        { bits: "1",
          name: "channel_error",
          desc: "Must be 0 in absence of errors"
        },
        { bits: "0",
          name: "channel_free",
          desc: "If 1 the agent own the channel, if 0 the platform own the channel"
        }
      ],
    },
    { name: "Reserved_2_c29",
      desc: "Reserved, implementation defined (32 bits over 64)",
      swaccess: "rw",
      hwaccess: "none",
      fields: [
        { bits: "31:0" }
      ],
    },
    { name: "Reserved_3_c29",
      desc: "Reserved, implementation defined (32 bits over 64)",
      swaccess: "none",
      hwaccess: "none",
      fields: [
        { bits: "31:0" }
      ],
    },
    { name: "Channel_Flags_c29",
      desc: "Defines wheter interrupts or polling is used for communication",
      swaccess: "rw",
      hwaccess: "none",
      fields: [
        { bits: "31:1" },
        { bits: "0",
          name: "intr_enable",
          desc: "If 1 interruts are used, if 0 polling is used"
        }
      ],
    },
    { name: "Length_c29",
      desc: "Lenght of payload + header",
      swaccess: "rw",
      hwaccess: "none",
      fields: [
        { bits: "31:0" }
      ],
    },
    { name: "Message_Header_c29",
      desc: "Defines which commanad the message contains",
      swaccess: "rw",
      hwaccess: "none",
      fields: [
        { bits: "31:28" },
        { bits: "27:18",
          name: "Token",
          desc: "must be same for the msg responses associated to a msg whith the same header"
        },
        { bits: "17:10",
          name: "Protocol_Id",
          desc: "Identifies to which protocol the command belongs to"
        },
        { bits: "9:8",
          name: "Message_Type",
          desc: "can be 0,1,2,3 depending on the kind of msg to be sent"
        },
        { bits: "7:0",
          name: "Message_Id",
          desc: "unique identifier for each command availabe in the protocol pointed by protocol_id"
        }
      ],
    },
    { name: "Message_Payload_1_c29",
      desc: "memory region dedicated to the parameters of the commands and their returns",
      swaccess: "rw",
      hwaccess: "none",
      fields: [
        { bits: "31:0" }
      ],
    },
    { name: "Doorbell_c29",
      desc: "Rapresents the interrupt to be raised towards the platform",
      swaccess: "rw",
      hwaccess: "hro",
      fields: [
        { bits: "31:1",
          name: "Preserve_Mask",
          desc: "These bits must be constant to 0, not used with just one platform and one agent"
        },
        { bits: "0",
          name: "intr",
          desc: "Interrupt bit"
        }
      ],
    },
    { name:  "Completion_Interrupt_c29",
      desc: "Rapresent the interrupt the platform should raise when it finishes to execute the received command",
      swaccess: "rw",
      hwaccess: "hro",
      fields: [
        { bits: "31:1",
          name: "Preserve_Mask",
          desc: "These bits must be constant to 0, not used with just one platform and one agent"
        },
        { bits: "0",
          name: "intr",
          desc: "Interrupt bit"
        }
      ],
    },
    { name: "Reserved_1_c30",
      desc: "Reserved, must be 0",
      swaccess: "rw",
      hwaccess: "none",
      fields: [
        { bits: "31:0" }
      ],
    },
    { name: "Channel_Status_c30",
      desc: "Indicates which entity has access to the Shared Memory",
      swaccess: "rw",
      hwaccess: "none",
      fields: [
        { bits: "31:2" },
        { bits: "1",
          name: "channel_error",
          desc: "Must be 0 in absence of errors"
        },
        { bits: "0",
          name: "channel_free",
          desc: "If 1 the agent own the channel, if 0 the platform own the channel"
        }
      ],
    },
    { name: "Reserved_2_c30",
      desc: "Reserved, implementation defined (32 bits over 64)",
      swaccess: "rw",
      hwaccess: "none",
      fields: [
        { bits: "31:0" }
      ],
    },
    { name: "Reserved_3_c30",
      desc: "Reserved, implementation defined (32 bits over 64)",
      swaccess: "none",
      hwaccess: "none",
      fields: [
        { bits: "31:0" }
      ],
    },
    { name: "Channel_Flags_c30",
      desc: "Defines wheter interrupts or polling is used for communication",
      swaccess: "rw",
      hwaccess: "none",
      fields: [
        { bits: "31:1" },
        { bits: "0",
          name: "intr_enable",
          desc: "If 1 interruts are used, if 0 polling is used"
        }
      ],
    },
    { name: "Length_c30",
      desc: "Lenght of payload + header",
      swaccess: "rw",
      hwaccess: "none",
      fields: [
        { bits: "31:0" }
      ],
    },
    { name: "Message_Header_c30",
      desc: "Defines which commanad the message contains",
      swaccess: "rw",
      hwaccess: "none",
      fields: [
        { bits: "31:28" },
        { bits: "27:18",
          name: "Token",
          desc: "must be same for the msg responses associated to a msg whith the same header"
        },
        { bits: "17:10",
          name: "Protocol_Id",
          desc: "Identifies to which protocol the command belongs to"
        },
        { bits: "9:8",
          name: "Message_Type",
          desc: "can be 0,1,2,3 depending on the kind of msg to be sent"
        },
        { bits: "7:0",
          name: "Message_Id",
          desc: "unique identifier for each command availabe in the protocol pointed by protocol_id"
        }
      ],
    },
    { name: "Message_Payload_1_c30",
      desc: "memory region dedicated to the parameters of the commands and their returns",
      swaccess: "rw",
      hwaccess: "none",
      fields: [
        { bits: "31:0" }
      ],
    },
    { name: "Doorbell_c30",
      desc: "Rapresents the interrupt to be raised towards the platform",
      swaccess: "rw",
      hwaccess: "hro",
      fields: [
        { bits: "31:1",
          name: "Preserve_Mask",
          desc: "These bits must be constant to 0, not used with just one platform and one agent"
        },
        { bits: "0",
          name: "intr",
          desc: "Interrupt bit"
        }
      ],
    },
    { name:  "Completion_Interrupt_c30",
      desc: "Rapresent the interrupt the platform should raise when it finishes to execute the received command",
      swaccess: "rw",
      hwaccess: "hro",
      fields: [
        { bits: "31:1",
          name: "Preserve_Mask",
          desc: "These bits must be constant to 0, not used with just one platform and one agent"
        },
        { bits: "0",
          name: "intr",
          desc: "Interrupt bit"
        }
      ],
    },
    { name: "Reserved_1_c31",
      desc: "Reserved, must be 0",
      swaccess: "rw",
      hwaccess: "none",
      fields: [
        { bits: "31:0" }
      ],
    },
    { name: "Channel_Status_c31",
      desc: "Indicates which entity has access to the Shared Memory",
      swaccess: "rw",
      hwaccess: "none",
      fields: [
        { bits: "31:2" },
        { bits: "1",
          name: "channel_error",
          desc: "Must be 0 in absence of errors"
        },
        { bits: "0",
          name: "channel_free",
          desc: "If 1 the agent own the channel, if 0 the platform own the channel"
        }
      ],
    },
    { name: "Reserved_2_c31",
      desc: "Reserved, implementation defined (32 bits over 64)",
      swaccess: "rw",
      hwaccess: "none",
      fields: [
        { bits: "31:0" }
      ],
    },
    { name: "Reserved_3_c31",
      desc: "Reserved, implementation defined (32 bits over 64)",
      swaccess: "none",
      hwaccess: "none",
      fields: [
        { bits: "31:0" }
      ],
    },
    { name: "Channel_Flags_c31",
      desc: "Defines wheter interrupts or polling is used for communication",
      swaccess: "rw",
      hwaccess: "none",
      fields: [
        { bits: "31:1" },
        { bits: "0",
          name: "intr_enable",
          desc: "If 1 interruts are used, if 0 polling is used"
        }
      ],
    },
    { name: "Length_c31",
      desc: "Lenght of payload + header",
      swaccess: "rw",
      hwaccess: "none",
      fields: [
        { bits: "31:0" }
      ],
    },
    { name: "Message_Header_c31",
      desc: "Defines which commanad the message contains",
      swaccess: "rw",
      hwaccess: "none",
      fields: [
        { bits: "31:28" },
        { bits: "27:18",
          name: "Token",
          desc: "must be same for the msg responses associated to a msg whith the same header"
        },
        { bits: "17:10",
          name: "Protocol_Id",
          desc: "Identifies to which protocol the command belongs to"
        },
        { bits: "9:8",
          name: "Message_Type",
          desc: "can be 0,1,2,3 depending on the kind of msg to be sent"
        },
        { bits: "7:0",
          name: "Message_Id",
          desc: "unique identifier for each command availabe in the protocol pointed by protocol_id"
        }
      ],
    },
    { name: "Message_Payload_1_c31",
      desc: "memory region dedicated to the parameters of the commands and their returns",
      swaccess: "rw",
      hwaccess: "none",
      fields: [
        { bits: "31:0" }
      ],
    },
    { name: "Doorbell_c31",
      desc: "Rapresents the interrupt to be raised towards the platform",
      swaccess: "rw",
      hwaccess: "hro",
      fields: [
        { bits: "31:1",
          name: "Preserve_Mask",
          desc: "These bits must be constant to 0, not used with just one platform and one agent"
        },
        { bits: "0",
          name: "intr",
          desc: "Interrupt bit"
        }
      ],
    },
    { name:  "Completion_Interrupt_c31",
      desc: "Rapresent the interrupt the platform should raise when it finishes to execute the received command",
      swaccess: "rw",
      hwaccess: "hro",
      fields: [
        { bits: "31:1",
          name: "Preserve_Mask",
          desc: "These bits must be constant to 0, not used with just one platform and one agent"
        },
        { bits: "0",
          name: "intr",
          desc: "Interrupt bit"
        }
      ],
    },
    { name: "Reserved_1_c32",
      desc: "Reserved, must be 0",
      swaccess: "rw",
      hwaccess: "none",
      fields: [
        { bits: "31:0" }
      ],
    },
    { name: "Channel_Status_c32",
      desc: "Indicates which entity has access to the Shared Memory",
      swaccess: "rw",
      hwaccess: "none",
      fields: [
        { bits: "31:2" },
        { bits: "1",
          name: "channel_error",
          desc: "Must be 0 in absence of errors"
        },
        { bits: "0",
          name: "channel_free",
          desc: "If 1 the agent own the channel, if 0 the platform own the channel"
        }
      ],
    },
    { name: "Reserved_2_c32",
      desc: "Reserved, implementation defined (32 bits over 64)",
      swaccess: "rw",
      hwaccess: "none",
      fields: [
        { bits: "31:0" }
      ],
    },
    { name: "Reserved_3_c32",
      desc: "Reserved, implementation defined (32 bits over 64)",
      swaccess: "none",
      hwaccess: "none",
      fields: [
        { bits: "31:0" }
      ],
    },
    { name: "Channel_Flags_c32",
      desc: "Defines wheter interrupts or polling is used for communication",
      swaccess: "rw",
      hwaccess: "none",
      fields: [
        { bits: "31:1" },
        { bits: "0",
          name: "intr_enable",
          desc: "If 1 interruts are used, if 0 polling is used"
        }
      ],
    },
    { name: "Length_c32",
      desc: "Lenght of payload + header",
      swaccess: "rw",
      hwaccess: "none",
      fields: [
        { bits: "31:0" }
      ],
    },
    { name: "Message_Header_c32",
      desc: "Defines which commanad the message contains",
      swaccess: "rw",
      hwaccess: "none",
      fields: [
        { bits: "31:28" },
        { bits: "27:18",
          name: "Token",
          desc: "must be same for the msg responses associated to a msg whith the same header"
        },
        { bits: "17:10",
          name: "Protocol_Id",
          desc: "Identifies to which protocol the command belongs to"
        },
        { bits: "9:8",
          name: "Message_Type",
          desc: "can be 0,1,2,3 depending on the kind of msg to be sent"
        },
        { bits: "7:0",
          name: "Message_Id",
          desc: "unique identifier for each command availabe in the protocol pointed by protocol_id"
        }
      ],
    },
    { name: "Message_Payload_1_c32",
      desc: "memory region dedicated to the parameters of the commands and their returns",
      swaccess: "rw",
      hwaccess: "none",
      fields: [
        { bits: "31:0" }
      ],
    },
    { name: "Doorbell_c32",
      desc: "Rapresents the interrupt to be raised towards the platform",
      swaccess: "rw",
      hwaccess: "hro",
      fields: [
        { bits: "31:1",
          name: "Preserve_Mask",
          desc: "These bits must be constant to 0, not used with just one platform and one agent"
        },
        { bits: "0",
          name: "intr",
          desc: "Interrupt bit"
        }
      ],
    },
    { name:  "Completion_Interrupt_c32",
      desc: "Rapresent the interrupt the platform should raise when it finishes to execute the received command",
      swaccess: "rw",
      hwaccess: "hro",
      fields: [
        { bits: "31:1",
          name: "Preserve_Mask",
          desc: "These bits must be constant to 0, not used with just one platform and one agent"
        },
        { bits: "0",
          name: "intr",
          desc: "Interrupt bit"
        }
      ],
    },
    { name: "Reserved_1_c33",
      desc: "Reserved, must be 0",
      swaccess: "rw",
      hwaccess: "none",
      fields: [
        { bits: "31:0" }
      ],
    },
    { name: "Channel_Status_c33",
      desc: "Indicates which entity has access to the Shared Memory",
      swaccess: "rw",
      hwaccess: "none",
      fields: [
        { bits: "31:2" },
        { bits: "1",
          name: "channel_error",
          desc: "Must be 0 in absence of errors"
        },
        { bits: "0",
          name: "channel_free",
          desc: "If 1 the agent own the channel, if 0 the platform own the channel"
        }
      ],
    },
    { name: "Reserved_2_c33",
      desc: "Reserved, implementation defined (32 bits over 64)",
      swaccess: "rw",
      hwaccess: "none",
      fields: [
        { bits: "31:0" }
      ],
    },
    { name: "Reserved_3_c33",
      desc: "Reserved, implementation defined (32 bits over 64)",
      swaccess: "none",
      hwaccess: "none",
      fields: [
        { bits: "31:0" }
      ],
    },
    { name: "Channel_Flags_c33",
      desc: "Defines wheter interrupts or polling is used for communication",
      swaccess: "rw",
      hwaccess: "none",
      fields: [
        { bits: "31:1" },
        { bits: "0",
          name: "intr_enable",
          desc: "If 1 interruts are used, if 0 polling is used"
        }
      ],
    },
    { name: "Length_c33",
      desc: "Lenght of payload + header",
      swaccess: "rw",
      hwaccess: "none",
      fields: [
        { bits: "31:0" }
      ],
    },
    { name: "Message_Header_c33",
      desc: "Defines which commanad the message contains",
      swaccess: "rw",
      hwaccess: "none",
      fields: [
        { bits: "31:28" },
        { bits: "27:18",
          name: "Token",
          desc: "must be same for the msg responses associated to a msg whith the same header"
        },
        { bits: "17:10",
          name: "Protocol_Id",
          desc: "Identifies to which protocol the command belongs to"
        },
        { bits: "9:8",
          name: "Message_Type",
          desc: "can be 0,1,2,3 depending on the kind of msg to be sent"
        },
        { bits: "7:0",
          name: "Message_Id",
          desc: "unique identifier for each command availabe in the protocol pointed by protocol_id"
        }
      ],
    },
    { name: "Message_Payload_1_c33",
      desc: "memory region dedicated to the parameters of the commands and their returns",
      swaccess: "rw",
      hwaccess: "none",
      fields: [
        { bits: "31:0" }
      ],
    },
    { name: "Doorbell_c33",
      desc: "Rapresents the interrupt to be raised towards the platform",
      swaccess: "rw",
      hwaccess: "hro",
      fields: [
        { bits: "31:1",
          name: "Preserve_Mask",
          desc: "These bits must be constant to 0, not used with just one platform and one agent"
        },
        { bits: "0",
          name: "intr",
          desc: "Interrupt bit"
        }
      ],
    },
    { name:  "Completion_Interrupt_c33",
      desc: "Rapresent the interrupt the platform should raise when it finishes to execute the received command",
      swaccess: "rw",
      hwaccess: "hro",
      fields: [
        { bits: "31:1",
          name: "Preserve_Mask",
          desc: "These bits must be constant to 0, not used with just one platform and one agent"
        },
        { bits: "0",
          name: "intr",
          desc: "Interrupt bit"
        }
      ],
    },
    { name: "Reserved_1_c34",
      desc: "Reserved, must be 0",
      swaccess: "rw",
      hwaccess: "none",
      fields: [
        { bits: "31:0" }
      ],
    },
    { name: "Channel_Status_c34",
      desc: "Indicates which entity has access to the Shared Memory",
      swaccess: "rw",
      hwaccess: "none",
      fields: [
        { bits: "31:2" },
        { bits: "1",
          name: "channel_error",
          desc: "Must be 0 in absence of errors"
        },
        { bits: "0",
          name: "channel_free",
          desc: "If 1 the agent own the channel, if 0 the platform own the channel"
        }
      ],
    },
    { name: "Reserved_2_c34",
      desc: "Reserved, implementation defined (32 bits over 64)",
      swaccess: "rw",
      hwaccess: "none",
      fields: [
        { bits: "31:0" }
      ],
    },
    { name: "Reserved_3_c34",
      desc: "Reserved, implementation defined (32 bits over 64)",
      swaccess: "none",
      hwaccess: "none",
      fields: [
        { bits: "31:0" }
      ],
    },
    { name: "Channel_Flags_c34",
      desc: "Defines wheter interrupts or polling is used for communication",
      swaccess: "rw",
      hwaccess: "none",
      fields: [
        { bits: "31:1" },
        { bits: "0",
          name: "intr_enable",
          desc: "If 1 interruts are used, if 0 polling is used"
        }
      ],
    },
    { name: "Length_c34",
      desc: "Lenght of payload + header",
      swaccess: "rw",
      hwaccess: "none",
      fields: [
        { bits: "31:0" }
      ],
    },
    { name: "Message_Header_c34",
      desc: "Defines which commanad the message contains",
      swaccess: "rw",
      hwaccess: "none",
      fields: [
        { bits: "31:28" },
        { bits: "27:18",
          name: "Token",
          desc: "must be same for the msg responses associated to a msg whith the same header"
        },
        { bits: "17:10",
          name: "Protocol_Id",
          desc: "Identifies to which protocol the command belongs to"
        },
        { bits: "9:8",
          name: "Message_Type",
          desc: "can be 0,1,2,3 depending on the kind of msg to be sent"
        },
        { bits: "7:0",
          name: "Message_Id",
          desc: "unique identifier for each command availabe in the protocol pointed by protocol_id"
        }
      ],
    },
    { name: "Message_Payload_1_c34",
      desc: "memory region dedicated to the parameters of the commands and their returns",
      swaccess: "rw",
      hwaccess: "none",
      fields: [
        { bits: "31:0" }
      ],
    },
    { name: "Doorbell_c34",
      desc: "Rapresents the interrupt to be raised towards the platform",
      swaccess: "rw",
      hwaccess: "hro",
      fields: [
        { bits: "31:1",
          name: "Preserve_Mask",
          desc: "These bits must be constant to 0, not used with just one platform and one agent"
        },
        { bits: "0",
          name: "intr",
          desc: "Interrupt bit"
        }
      ],
    },
    { name:  "Completion_Interrupt_c34",
      desc: "Rapresent the interrupt the platform should raise when it finishes to execute the received command",
      swaccess: "rw",
      hwaccess: "hro",
      fields: [
        { bits: "31:1",
          name: "Preserve_Mask",
          desc: "These bits must be constant to 0, not used with just one platform and one agent"
        },
        { bits: "0",
          name: "intr",
          desc: "Interrupt bit"
        }
      ],
    },
    { name: "Reserved_1_c35",
      desc: "Reserved, must be 0",
      swaccess: "rw",
      hwaccess: "none",
      fields: [
        { bits: "31:0" }
      ],
    },
    { name: "Channel_Status_c35",
      desc: "Indicates which entity has access to the Shared Memory",
      swaccess: "rw",
      hwaccess: "none",
      fields: [
        { bits: "31:2" },
        { bits: "1",
          name: "channel_error",
          desc: "Must be 0 in absence of errors"
        },
        { bits: "0",
          name: "channel_free",
          desc: "If 1 the agent own the channel, if 0 the platform own the channel"
        }
      ],
    },
    { name: "Reserved_2_c35",
      desc: "Reserved, implementation defined (32 bits over 64)",
      swaccess: "rw",
      hwaccess: "none",
      fields: [
        { bits: "31:0" }
      ],
    },
    { name: "Reserved_3_c35",
      desc: "Reserved, implementation defined (32 bits over 64)",
      swaccess: "none",
      hwaccess: "none",
      fields: [
        { bits: "31:0" }
      ],
    },
    { name: "Channel_Flags_c35",
      desc: "Defines wheter interrupts or polling is used for communication",
      swaccess: "rw",
      hwaccess: "none",
      fields: [
        { bits: "31:1" },
        { bits: "0",
          name: "intr_enable",
          desc: "If 1 interruts are used, if 0 polling is used"
        }
      ],
    },
    { name: "Length_c35",
      desc: "Lenght of payload + header",
      swaccess: "rw",
      hwaccess: "none",
      fields: [
        { bits: "31:0" }
      ],
    },
    { name: "Message_Header_c35",
      desc: "Defines which commanad the message contains",
      swaccess: "rw",
      hwaccess: "none",
      fields: [
        { bits: "31:28" },
        { bits: "27:18",
          name: "Token",
          desc: "must be same for the msg responses associated to a msg whith the same header"
        },
        { bits: "17:10",
          name: "Protocol_Id",
          desc: "Identifies to which protocol the command belongs to"
        },
        { bits: "9:8",
          name: "Message_Type",
          desc: "can be 0,1,2,3 depending on the kind of msg to be sent"
        },
        { bits: "7:0",
          name: "Message_Id",
          desc: "unique identifier for each command availabe in the protocol pointed by protocol_id"
        }
      ],
    },
    { name: "Message_Payload_1_c35",
      desc: "memory region dedicated to the parameters of the commands and their returns",
      swaccess: "rw",
      hwaccess: "none",
      fields: [
        { bits: "31:0" }
      ],
    },
    { name: "Doorbell_c35",
      desc: "Rapresents the interrupt to be raised towards the platform",
      swaccess: "rw",
      hwaccess: "hro",
      fields: [
        { bits: "31:1",
          name: "Preserve_Mask",
          desc: "These bits must be constant to 0, not used with just one platform and one agent"
        },
        { bits: "0",
          name: "intr",
          desc: "Interrupt bit"
        }
      ],
    },
    { name:  "Completion_Interrupt_c35",
      desc: "Rapresent the interrupt the platform should raise when it finishes to execute the received command",
      swaccess: "rw",
      hwaccess: "hro",
      fields: [
        { bits: "31:1",
          name: "Preserve_Mask",
          desc: "These bits must be constant to 0, not used with just one platform and one agent"
        },
        { bits: "0",
          name: "intr",
          desc: "Interrupt bit"
        }
      ],
    },
    { name: "Reserved_1_c36",
      desc: "Reserved, must be 0",
      swaccess: "rw",
      hwaccess: "none",
      fields: [
        { bits: "31:0" }
      ],
    },
    { name: "Channel_Status_c36",
      desc: "Indicates which entity has access to the Shared Memory",
      swaccess: "rw",
      hwaccess: "none",
      fields: [
        { bits: "31:2" },
        { bits: "1",
          name: "channel_error",
          desc: "Must be 0 in absence of errors"
        },
        { bits: "0",
          name: "channel_free",
          desc: "If 1 the agent own the channel, if 0 the platform own the channel"
        }
      ],
    },
    { name: "Reserved_2_c36",
      desc: "Reserved, implementation defined (32 bits over 64)",
      swaccess: "rw",
      hwaccess: "none",
      fields: [
        { bits: "31:0" }
      ],
    },
    { name: "Reserved_3_c36",
      desc: "Reserved, implementation defined (32 bits over 64)",
      swaccess: "none",
      hwaccess: "none",
      fields: [
        { bits: "31:0" }
      ],
    },
    { name: "Channel_Flags_c36",
      desc: "Defines wheter interrupts or polling is used for communication",
      swaccess: "rw",
      hwaccess: "none",
      fields: [
        { bits: "31:1" },
        { bits: "0",
          name: "intr_enable",
          desc: "If 1 interruts are used, if 0 polling is used"
        }
      ],
    },
    { name: "Length_c36",
      desc: "Lenght of payload + header",
      swaccess: "rw",
      hwaccess: "none",
      fields: [
        { bits: "31:0" }
      ],
    },
    { name: "Message_Header_c36",
      desc: "Defines which commanad the message contains",
      swaccess: "rw",
      hwaccess: "none",
      fields: [
        { bits: "31:28" },
        { bits: "27:18",
          name: "Token",
          desc: "must be same for the msg responses associated to a msg whith the same header"
        },
        { bits: "17:10",
          name: "Protocol_Id",
          desc: "Identifies to which protocol the command belongs to"
        },
        { bits: "9:8",
          name: "Message_Type",
          desc: "can be 0,1,2,3 depending on the kind of msg to be sent"
        },
        { bits: "7:0",
          name: "Message_Id",
          desc: "unique identifier for each command availabe in the protocol pointed by protocol_id"
        }
      ],
    },
    { name: "Message_Payload_1_c36",
      desc: "memory region dedicated to the parameters of the commands and their returns",
      swaccess: "rw",
      hwaccess: "none",
      fields: [
        { bits: "31:0" }
      ],
    },
    { name: "Doorbell_c36",
      desc: "Rapresents the interrupt to be raised towards the platform",
      swaccess: "rw",
      hwaccess: "hro",
      fields: [
        { bits: "31:1",
          name: "Preserve_Mask",
          desc: "These bits must be constant to 0, not used with just one platform and one agent"
        },
        { bits: "0",
          name: "intr",
          desc: "Interrupt bit"
        }
      ],
    },
    { name:  "Completion_Interrupt_c36",
      desc: "Rapresent the interrupt the platform should raise when it finishes to execute the received command",
      swaccess: "rw",
      hwaccess: "hro",
      fields: [
        { bits: "31:1",
          name: "Preserve_Mask",
          desc: "These bits must be constant to 0, not used with just one platform and one agent"
        },
        { bits: "0",
          name: "intr",
          desc: "Interrupt bit"
        }
      ],
    },
    { name: "Reserved_1_c37",
      desc: "Reserved, must be 0",
      swaccess: "rw",
      hwaccess: "none",
      fields: [
        { bits: "31:0" }
      ],
    },
    { name: "Channel_Status_c37",
      desc: "Indicates which entity has access to the Shared Memory",
      swaccess: "rw",
      hwaccess: "none",
      fields: [
        { bits: "31:2" },
        { bits: "1",
          name: "channel_error",
          desc: "Must be 0 in absence of errors"
        },
        { bits: "0",
          name: "channel_free",
          desc: "If 1 the agent own the channel, if 0 the platform own the channel"
        }
      ],
    },
    { name: "Reserved_2_c37",
      desc: "Reserved, implementation defined (32 bits over 64)",
      swaccess: "rw",
      hwaccess: "none",
      fields: [
        { bits: "31:0" }
      ],
    },
    { name: "Reserved_3_c37",
      desc: "Reserved, implementation defined (32 bits over 64)",
      swaccess: "none",
      hwaccess: "none",
      fields: [
        { bits: "31:0" }
      ],
    },
    { name: "Channel_Flags_c37",
      desc: "Defines wheter interrupts or polling is used for communication",
      swaccess: "rw",
      hwaccess: "none",
      fields: [
        { bits: "31:1" },
        { bits: "0",
          name: "intr_enable",
          desc: "If 1 interruts are used, if 0 polling is used"
        }
      ],
    },
    { name: "Length_c37",
      desc: "Lenght of payload + header",
      swaccess: "rw",
      hwaccess: "none",
      fields: [
        { bits: "31:0" }
      ],
    },
    { name: "Message_Header_c37",
      desc: "Defines which commanad the message contains",
      swaccess: "rw",
      hwaccess: "none",
      fields: [
        { bits: "31:28" },
        { bits: "27:18",
          name: "Token",
          desc: "must be same for the msg responses associated to a msg whith the same header"
        },
        { bits: "17:10",
          name: "Protocol_Id",
          desc: "Identifies to which protocol the command belongs to"
        },
        { bits: "9:8",
          name: "Message_Type",
          desc: "can be 0,1,2,3 depending on the kind of msg to be sent"
        },
        { bits: "7:0",
          name: "Message_Id",
          desc: "unique identifier for each command availabe in the protocol pointed by protocol_id"
        }
      ],
    },
    { name: "Message_Payload_1_c37",
      desc: "memory region dedicated to the parameters of the commands and their returns",
      swaccess: "rw",
      hwaccess: "none",
      fields: [
        { bits: "31:0" }
      ],
    },
    { name: "Doorbell_c37",
      desc: "Rapresents the interrupt to be raised towards the platform",
      swaccess: "rw",
      hwaccess: "hro",
      fields: [
        { bits: "31:1",
          name: "Preserve_Mask",
          desc: "These bits must be constant to 0, not used with just one platform and one agent"
        },
        { bits: "0",
          name: "intr",
          desc: "Interrupt bit"
        }
      ],
    },
    { name:  "Completion_Interrupt_c37",
      desc: "Rapresent the interrupt the platform should raise when it finishes to execute the received command",
      swaccess: "rw",
      hwaccess: "hro",
      fields: [
        { bits: "31:1",
          name: "Preserve_Mask",
          desc: "These bits must be constant to 0, not used with just one platform and one agent"
        },
        { bits: "0",
          name: "intr",
          desc: "Interrupt bit"
        }
      ],
    },
    { name: "Reserved_1_c38",
      desc: "Reserved, must be 0",
      swaccess: "rw",
      hwaccess: "none",
      fields: [
        { bits: "31:0" }
      ],
    },
    { name: "Channel_Status_c38",
      desc: "Indicates which entity has access to the Shared Memory",
      swaccess: "rw",
      hwaccess: "none",
      fields: [
        { bits: "31:2" },
        { bits: "1",
          name: "channel_error",
          desc: "Must be 0 in absence of errors"
        },
        { bits: "0",
          name: "channel_free",
          desc: "If 1 the agent own the channel, if 0 the platform own the channel"
        }
      ],
    },
    { name: "Reserved_2_c38",
      desc: "Reserved, implementation defined (32 bits over 64)",
      swaccess: "rw",
      hwaccess: "none",
      fields: [
        { bits: "31:0" }
      ],
    },
    { name: "Reserved_3_c38",
      desc: "Reserved, implementation defined (32 bits over 64)",
      swaccess: "none",
      hwaccess: "none",
      fields: [
        { bits: "31:0" }
      ],
    },
    { name: "Channel_Flags_c38",
      desc: "Defines wheter interrupts or polling is used for communication",
      swaccess: "rw",
      hwaccess: "none",
      fields: [
        { bits: "31:1" },
        { bits: "0",
          name: "intr_enable",
          desc: "If 1 interruts are used, if 0 polling is used"
        }
      ],
    },
    { name: "Length_c38",
      desc: "Lenght of payload + header",
      swaccess: "rw",
      hwaccess: "none",
      fields: [
        { bits: "31:0" }
      ],
    },
    { name: "Message_Header_c38",
      desc: "Defines which commanad the message contains",
      swaccess: "rw",
      hwaccess: "none",
      fields: [
        { bits: "31:28" },
        { bits: "27:18",
          name: "Token",
          desc: "must be same for the msg responses associated to a msg whith the same header"
        },
        { bits: "17:10",
          name: "Protocol_Id",
          desc: "Identifies to which protocol the command belongs to"
        },
        { bits: "9:8",
          name: "Message_Type",
          desc: "can be 0,1,2,3 depending on the kind of msg to be sent"
        },
        { bits: "7:0",
          name: "Message_Id",
          desc: "unique identifier for each command availabe in the protocol pointed by protocol_id"
        }
      ],
    },
    { name: "Message_Payload_1_c38",
      desc: "memory region dedicated to the parameters of the commands and their returns",
      swaccess: "rw",
      hwaccess: "none",
      fields: [
        { bits: "31:0" }
      ],
    },
    { name: "Doorbell_c38",
      desc: "Rapresents the interrupt to be raised towards the platform",
      swaccess: "rw",
      hwaccess: "hro",
      fields: [
        { bits: "31:1",
          name: "Preserve_Mask",
          desc: "These bits must be constant to 0, not used with just one platform and one agent"
        },
        { bits: "0",
          name: "intr",
          desc: "Interrupt bit"
        }
      ],
    },
    { name:  "Completion_Interrupt_c38",
      desc: "Rapresent the interrupt the platform should raise when it finishes to execute the received command",
      swaccess: "rw",
      hwaccess: "hro",
      fields: [
        { bits: "31:1",
          name: "Preserve_Mask",
          desc: "These bits must be constant to 0, not used with just one platform and one agent"
        },
        { bits: "0",
          name: "intr",
          desc: "Interrupt bit"
        }
      ],
    },
    { name: "Reserved_1_c39",
      desc: "Reserved, must be 0",
      swaccess: "rw",
      hwaccess: "none",
      fields: [
        { bits: "31:0" }
      ],
    },
    { name: "Channel_Status_c39",
      desc: "Indicates which entity has access to the Shared Memory",
      swaccess: "rw",
      hwaccess: "none",
      fields: [
        { bits: "31:2" },
        { bits: "1",
          name: "channel_error",
          desc: "Must be 0 in absence of errors"
        },
        { bits: "0",
          name: "channel_free",
          desc: "If 1 the agent own the channel, if 0 the platform own the channel"
        }
      ],
    },
    { name: "Reserved_2_c39",
      desc: "Reserved, implementation defined (32 bits over 64)",
      swaccess: "rw",
      hwaccess: "none",
      fields: [
        { bits: "31:0" }
      ],
    },
    { name: "Reserved_3_c39",
      desc: "Reserved, implementation defined (32 bits over 64)",
      swaccess: "none",
      hwaccess: "none",
      fields: [
        { bits: "31:0" }
      ],
    },
    { name: "Channel_Flags_c39",
      desc: "Defines wheter interrupts or polling is used for communication",
      swaccess: "rw",
      hwaccess: "none",
      fields: [
        { bits: "31:1" },
        { bits: "0",
          name: "intr_enable",
          desc: "If 1 interruts are used, if 0 polling is used"
        }
      ],
    },
    { name: "Length_c39",
      desc: "Lenght of payload + header",
      swaccess: "rw",
      hwaccess: "none",
      fields: [
        { bits: "31:0" }
      ],
    },
    { name: "Message_Header_c39",
      desc: "Defines which commanad the message contains",
      swaccess: "rw",
      hwaccess: "none",
      fields: [
        { bits: "31:28" },
        { bits: "27:18",
          name: "Token",
          desc: "must be same for the msg responses associated to a msg whith the same header"
        },
        { bits: "17:10",
          name: "Protocol_Id",
          desc: "Identifies to which protocol the command belongs to"
        },
        { bits: "9:8",
          name: "Message_Type",
          desc: "can be 0,1,2,3 depending on the kind of msg to be sent"
        },
        { bits: "7:0",
          name: "Message_Id",
          desc: "unique identifier for each command availabe in the protocol pointed by protocol_id"
        }
      ],
    },
    { name: "Message_Payload_1_c39",
      desc: "memory region dedicated to the parameters of the commands and their returns",
      swaccess: "rw",
      hwaccess: "none",
      fields: [
        { bits: "31:0" }
      ],
    },
    { name: "Doorbell_c39",
      desc: "Rapresents the interrupt to be raised towards the platform",
      swaccess: "rw",
      hwaccess: "hro",
      fields: [
        { bits: "31:1",
          name: "Preserve_Mask",
          desc: "These bits must be constant to 0, not used with just one platform and one agent"
        },
        { bits: "0",
          name: "intr",
          desc: "Interrupt bit"
        }
      ],
    },
    { name:  "Completion_Interrupt_c39",
      desc: "Rapresent the interrupt the platform should raise when it finishes to execute the received command",
      swaccess: "rw",
      hwaccess: "hro",
      fields: [
        { bits: "31:1",
          name: "Preserve_Mask",
          desc: "These bits must be constant to 0, not used with just one platform and one agent"
        },
        { bits: "0",
          name: "intr",
          desc: "Interrupt bit"
        }
      ],
    },
    { name: "Reserved_1_c40",
      desc: "Reserved, must be 0",
      swaccess: "rw",
      hwaccess: "none",
      fields: [
        { bits: "31:0" }
      ],
    },
    { name: "Channel_Status_c40",
      desc: "Indicates which entity has access to the Shared Memory",
      swaccess: "rw",
      hwaccess: "none",
      fields: [
        { bits: "31:2" },
        { bits: "1",
          name: "channel_error",
          desc: "Must be 0 in absence of errors"
        },
        { bits: "0",
          name: "channel_free",
          desc: "If 1 the agent own the channel, if 0 the platform own the channel"
        }
      ],
    },
    { name: "Reserved_2_c40",
      desc: "Reserved, implementation defined (32 bits over 64)",
      swaccess: "rw",
      hwaccess: "none",
      fields: [
        { bits: "31:0" }
      ],
    },
    { name: "Reserved_3_c40",
      desc: "Reserved, implementation defined (32 bits over 64)",
      swaccess: "none",
      hwaccess: "none",
      fields: [
        { bits: "31:0" }
      ],
    },
    { name: "Channel_Flags_c40",
      desc: "Defines wheter interrupts or polling is used for communication",
      swaccess: "rw",
      hwaccess: "none",
      fields: [
        { bits: "31:1" },
        { bits: "0",
          name: "intr_enable",
          desc: "If 1 interruts are used, if 0 polling is used"
        }
      ],
    },
    { name: "Length_c40",
      desc: "Lenght of payload + header",
      swaccess: "rw",
      hwaccess: "none",
      fields: [
        { bits: "31:0" }
      ],
    },
    { name: "Message_Header_c40",
      desc: "Defines which commanad the message contains",
      swaccess: "rw",
      hwaccess: "none",
      fields: [
        { bits: "31:28" },
        { bits: "27:18",
          name: "Token",
          desc: "must be same for the msg responses associated to a msg whith the same header"
        },
        { bits: "17:10",
          name: "Protocol_Id",
          desc: "Identifies to which protocol the command belongs to"
        },
        { bits: "9:8",
          name: "Message_Type",
          desc: "can be 0,1,2,3 depending on the kind of msg to be sent"
        },
        { bits: "7:0",
          name: "Message_Id",
          desc: "unique identifier for each command availabe in the protocol pointed by protocol_id"
        }
      ],
    },
    { name: "Message_Payload_1_c40",
      desc: "memory region dedicated to the parameters of the commands and their returns",
      swaccess: "rw",
      hwaccess: "none",
      fields: [
        { bits: "31:0" }
      ],
    },
    { name: "Doorbell_c40",
      desc: "Rapresents the interrupt to be raised towards the platform",
      swaccess: "rw",
      hwaccess: "hro",
      fields: [
        { bits: "31:1",
          name: "Preserve_Mask",
          desc: "These bits must be constant to 0, not used with just one platform and one agent"
        },
        { bits: "0",
          name: "intr",
          desc: "Interrupt bit"
        }
      ],
    },
    { name:  "Completion_Interrupt_c40",
      desc: "Rapresent the interrupt the platform should raise when it finishes to execute the received command",
      swaccess: "rw",
      hwaccess: "hro",
      fields: [
        { bits: "31:1",
          name: "Preserve_Mask",
          desc: "These bits must be constant to 0, not used with just one platform and one agent"
        },
        { bits: "0",
          name: "intr",
          desc: "Interrupt bit"
        }
      ],
    },
    { name: "Reserved_1_c41",
      desc: "Reserved, must be 0",
      swaccess: "rw",
      hwaccess: "none",
      fields: [
        { bits: "31:0" }
      ],
    },
    { name: "Channel_Status_c41",
      desc: "Indicates which entity has access to the Shared Memory",
      swaccess: "rw",
      hwaccess: "none",
      fields: [
        { bits: "31:2" },
        { bits: "1",
          name: "channel_error",
          desc: "Must be 0 in absence of errors"
        },
        { bits: "0",
          name: "channel_free",
          desc: "If 1 the agent own the channel, if 0 the platform own the channel"
        }
      ],
    },
    { name: "Reserved_2_c41",
      desc: "Reserved, implementation defined (32 bits over 64)",
      swaccess: "rw",
      hwaccess: "none",
      fields: [
        { bits: "31:0" }
      ],
    },
    { name: "Reserved_3_c41",
      desc: "Reserved, implementation defined (32 bits over 64)",
      swaccess: "none",
      hwaccess: "none",
      fields: [
        { bits: "31:0" }
      ],
    },
    { name: "Channel_Flags_c41",
      desc: "Defines wheter interrupts or polling is used for communication",
      swaccess: "rw",
      hwaccess: "none",
      fields: [
        { bits: "31:1" },
        { bits: "0",
          name: "intr_enable",
          desc: "If 1 interruts are used, if 0 polling is used"
        }
      ],
    },
    { name: "Length_c41",
      desc: "Lenght of payload + header",
      swaccess: "rw",
      hwaccess: "none",
      fields: [
        { bits: "31:0" }
      ],
    },
    { name: "Message_Header_c41",
      desc: "Defines which commanad the message contains",
      swaccess: "rw",
      hwaccess: "none",
      fields: [
        { bits: "31:28" },
        { bits: "27:18",
          name: "Token",
          desc: "must be same for the msg responses associated to a msg whith the same header"
        },
        { bits: "17:10",
          name: "Protocol_Id",
          desc: "Identifies to which protocol the command belongs to"
        },
        { bits: "9:8",
          name: "Message_Type",
          desc: "can be 0,1,2,3 depending on the kind of msg to be sent"
        },
        { bits: "7:0",
          name: "Message_Id",
          desc: "unique identifier for each command availabe in the protocol pointed by protocol_id"
        }
      ],
    },
    { name: "Message_Payload_1_c41",
      desc: "memory region dedicated to the parameters of the commands and their returns",
      swaccess: "rw",
      hwaccess: "none",
      fields: [
        { bits: "31:0" }
      ],
    },
    { name: "Doorbell_c41",
      desc: "Rapresents the interrupt to be raised towards the platform",
      swaccess: "rw",
      hwaccess: "hro",
      fields: [
        { bits: "31:1",
          name: "Preserve_Mask",
          desc: "These bits must be constant to 0, not used with just one platform and one agent"
        },
        { bits: "0",
          name: "intr",
          desc: "Interrupt bit"
        }
      ],
    },
    { name:  "Completion_Interrupt_c41",
      desc: "Rapresent the interrupt the platform should raise when it finishes to execute the received command",
      swaccess: "rw",
      hwaccess: "hro",
      fields: [
        { bits: "31:1",
          name: "Preserve_Mask",
          desc: "These bits must be constant to 0, not used with just one platform and one agent"
        },
        { bits: "0",
          name: "intr",
          desc: "Interrupt bit"
        }
      ],
    },
    { name: "Reserved_1_c42",
      desc: "Reserved, must be 0",
      swaccess: "rw",
      hwaccess: "none",
      fields: [
        { bits: "31:0" }
      ],
    },
    { name: "Channel_Status_c42",
      desc: "Indicates which entity has access to the Shared Memory",
      swaccess: "rw",
      hwaccess: "none",
      fields: [
        { bits: "31:2" },
        { bits: "1",
          name: "channel_error",
          desc: "Must be 0 in absence of errors"
        },
        { bits: "0",
          name: "channel_free",
          desc: "If 1 the agent own the channel, if 0 the platform own the channel"
        }
      ],
    },
    { name: "Reserved_2_c42",
      desc: "Reserved, implementation defined (32 bits over 64)",
      swaccess: "rw",
      hwaccess: "none",
      fields: [
        { bits: "31:0" }
      ],
    },
    { name: "Reserved_3_c42",
      desc: "Reserved, implementation defined (32 bits over 64)",
      swaccess: "none",
      hwaccess: "none",
      fields: [
        { bits: "31:0" }
      ],
    },
    { name: "Channel_Flags_c42",
      desc: "Defines wheter interrupts or polling is used for communication",
      swaccess: "rw",
      hwaccess: "none",
      fields: [
        { bits: "31:1" },
        { bits: "0",
          name: "intr_enable",
          desc: "If 1 interruts are used, if 0 polling is used"
        }
      ],
    },
    { name: "Length_c42",
      desc: "Lenght of payload + header",
      swaccess: "rw",
      hwaccess: "none",
      fields: [
        { bits: "31:0" }
      ],
    },
    { name: "Message_Header_c42",
      desc: "Defines which commanad the message contains",
      swaccess: "rw",
      hwaccess: "none",
      fields: [
        { bits: "31:28" },
        { bits: "27:18",
          name: "Token",
          desc: "must be same for the msg responses associated to a msg whith the same header"
        },
        { bits: "17:10",
          name: "Protocol_Id",
          desc: "Identifies to which protocol the command belongs to"
        },
        { bits: "9:8",
          name: "Message_Type",
          desc: "can be 0,1,2,3 depending on the kind of msg to be sent"
        },
        { bits: "7:0",
          name: "Message_Id",
          desc: "unique identifier for each command availabe in the protocol pointed by protocol_id"
        }
      ],
    },
    { name: "Message_Payload_1_c42",
      desc: "memory region dedicated to the parameters of the commands and their returns",
      swaccess: "rw",
      hwaccess: "none",
      fields: [
        { bits: "31:0" }
      ],
    },
    { name: "Doorbell_c42",
      desc: "Rapresents the interrupt to be raised towards the platform",
      swaccess: "rw",
      hwaccess: "hro",
      fields: [
        { bits: "31:1",
          name: "Preserve_Mask",
          desc: "These bits must be constant to 0, not used with just one platform and one agent"
        },
        { bits: "0",
          name: "intr",
          desc: "Interrupt bit"
        }
      ],
    },
    { name:  "Completion_Interrupt_c42",
      desc: "Rapresent the interrupt the platform should raise when it finishes to execute the received command",
      swaccess: "rw",
      hwaccess: "hro",
      fields: [
        { bits: "31:1",
          name: "Preserve_Mask",
          desc: "These bits must be constant to 0, not used with just one platform and one agent"
        },
        { bits: "0",
          name: "intr",
          desc: "Interrupt bit"
        }
      ],
    },
    { name: "Reserved_1_c43",
      desc: "Reserved, must be 0",
      swaccess: "rw",
      hwaccess: "none",
      fields: [
        { bits: "31:0" }
      ],
    },
    { name: "Channel_Status_c43",
      desc: "Indicates which entity has access to the Shared Memory",
      swaccess: "rw",
      hwaccess: "none",
      fields: [
        { bits: "31:2" },
        { bits: "1",
          name: "channel_error",
          desc: "Must be 0 in absence of errors"
        },
        { bits: "0",
          name: "channel_free",
          desc: "If 1 the agent own the channel, if 0 the platform own the channel"
        }
      ],
    },
    { name: "Reserved_2_c43",
      desc: "Reserved, implementation defined (32 bits over 64)",
      swaccess: "rw",
      hwaccess: "none",
      fields: [
        { bits: "31:0" }
      ],
    },
    { name: "Reserved_3_c43",
      desc: "Reserved, implementation defined (32 bits over 64)",
      swaccess: "none",
      hwaccess: "none",
      fields: [
        { bits: "31:0" }
      ],
    },
    { name: "Channel_Flags_c43",
      desc: "Defines wheter interrupts or polling is used for communication",
      swaccess: "rw",
      hwaccess: "none",
      fields: [
        { bits: "31:1" },
        { bits: "0",
          name: "intr_enable",
          desc: "If 1 interruts are used, if 0 polling is used"
        }
      ],
    },
    { name: "Length_c43",
      desc: "Lenght of payload + header",
      swaccess: "rw",
      hwaccess: "none",
      fields: [
        { bits: "31:0" }
      ],
    },
    { name: "Message_Header_c43",
      desc: "Defines which commanad the message contains",
      swaccess: "rw",
      hwaccess: "none",
      fields: [
        { bits: "31:28" },
        { bits: "27:18",
          name: "Token",
          desc: "must be same for the msg responses associated to a msg whith the same header"
        },
        { bits: "17:10",
          name: "Protocol_Id",
          desc: "Identifies to which protocol the command belongs to"
        },
        { bits: "9:8",
          name: "Message_Type",
          desc: "can be 0,1,2,3 depending on the kind of msg to be sent"
        },
        { bits: "7:0",
          name: "Message_Id",
          desc: "unique identifier for each command availabe in the protocol pointed by protocol_id"
        }
      ],
    },
    { name: "Message_Payload_1_c43",
      desc: "memory region dedicated to the parameters of the commands and their returns",
      swaccess: "rw",
      hwaccess: "none",
      fields: [
        { bits: "31:0" }
      ],
    },
    { name: "Doorbell_c43",
      desc: "Rapresents the interrupt to be raised towards the platform",
      swaccess: "rw",
      hwaccess: "hro",
      fields: [
        { bits: "31:1",
          name: "Preserve_Mask",
          desc: "These bits must be constant to 0, not used with just one platform and one agent"
        },
        { bits: "0",
          name: "intr",
          desc: "Interrupt bit"
        }
      ],
    },
    { name:  "Completion_Interrupt_c43",
      desc: "Rapresent the interrupt the platform should raise when it finishes to execute the received command",
      swaccess: "rw",
      hwaccess: "hro",
      fields: [
        { bits: "31:1",
          name: "Preserve_Mask",
          desc: "These bits must be constant to 0, not used with just one platform and one agent"
        },
        { bits: "0",
          name: "intr",
          desc: "Interrupt bit"
        }
      ],
    },
    { name: "Reserved_1_c44",
      desc: "Reserved, must be 0",
      swaccess: "rw",
      hwaccess: "none",
      fields: [
        { bits: "31:0" }
      ],
    },
    { name: "Channel_Status_c44",
      desc: "Indicates which entity has access to the Shared Memory",
      swaccess: "rw",
      hwaccess: "none",
      fields: [
        { bits: "31:2" },
        { bits: "1",
          name: "channel_error",
          desc: "Must be 0 in absence of errors"
        },
        { bits: "0",
          name: "channel_free",
          desc: "If 1 the agent own the channel, if 0 the platform own the channel"
        }
      ],
    },
    { name: "Reserved_2_c44",
      desc: "Reserved, implementation defined (32 bits over 64)",
      swaccess: "rw",
      hwaccess: "none",
      fields: [
        { bits: "31:0" }
      ],
    },
    { name: "Reserved_3_c44",
      desc: "Reserved, implementation defined (32 bits over 64)",
      swaccess: "none",
      hwaccess: "none",
      fields: [
        { bits: "31:0" }
      ],
    },
    { name: "Channel_Flags_c44",
      desc: "Defines wheter interrupts or polling is used for communication",
      swaccess: "rw",
      hwaccess: "none",
      fields: [
        { bits: "31:1" },
        { bits: "0",
          name: "intr_enable",
          desc: "If 1 interruts are used, if 0 polling is used"
        }
      ],
    },
    { name: "Length_c44",
      desc: "Lenght of payload + header",
      swaccess: "rw",
      hwaccess: "none",
      fields: [
        { bits: "31:0" }
      ],
    },
    { name: "Message_Header_c44",
      desc: "Defines which commanad the message contains",
      swaccess: "rw",
      hwaccess: "none",
      fields: [
        { bits: "31:28" },
        { bits: "27:18",
          name: "Token",
          desc: "must be same for the msg responses associated to a msg whith the same header"
        },
        { bits: "17:10",
          name: "Protocol_Id",
          desc: "Identifies to which protocol the command belongs to"
        },
        { bits: "9:8",
          name: "Message_Type",
          desc: "can be 0,1,2,3 depending on the kind of msg to be sent"
        },
        { bits: "7:0",
          name: "Message_Id",
          desc: "unique identifier for each command availabe in the protocol pointed by protocol_id"
        }
      ],
    },
    { name: "Message_Payload_1_c44",
      desc: "memory region dedicated to the parameters of the commands and their returns",
      swaccess: "rw",
      hwaccess: "none",
      fields: [
        { bits: "31:0" }
      ],
    },
    { name: "Doorbell_c44",
      desc: "Rapresents the interrupt to be raised towards the platform",
      swaccess: "rw",
      hwaccess: "hro",
      fields: [
        { bits: "31:1",
          name: "Preserve_Mask",
          desc: "These bits must be constant to 0, not used with just one platform and one agent"
        },
        { bits: "0",
          name: "intr",
          desc: "Interrupt bit"
        }
      ],
    },
    { name:  "Completion_Interrupt_c44",
      desc: "Rapresent the interrupt the platform should raise when it finishes to execute the received command",
      swaccess: "rw",
      hwaccess: "hro",
      fields: [
        { bits: "31:1",
          name: "Preserve_Mask",
          desc: "These bits must be constant to 0, not used with just one platform and one agent"
        },
        { bits: "0",
          name: "intr",
          desc: "Interrupt bit"
        }
      ],
    },
    { name: "Reserved_1_c45",
      desc: "Reserved, must be 0",
      swaccess: "rw",
      hwaccess: "none",
      fields: [
        { bits: "31:0" }
      ],
    },
    { name: "Channel_Status_c45",
      desc: "Indicates which entity has access to the Shared Memory",
      swaccess: "rw",
      hwaccess: "none",
      fields: [
        { bits: "31:2" },
        { bits: "1",
          name: "channel_error",
          desc: "Must be 0 in absence of errors"
        },
        { bits: "0",
          name: "channel_free",
          desc: "If 1 the agent own the channel, if 0 the platform own the channel"
        }
      ],
    },
    { name: "Reserved_2_c45",
      desc: "Reserved, implementation defined (32 bits over 64)",
      swaccess: "rw",
      hwaccess: "none",
      fields: [
        { bits: "31:0" }
      ],
    },
    { name: "Reserved_3_c45",
      desc: "Reserved, implementation defined (32 bits over 64)",
      swaccess: "none",
      hwaccess: "none",
      fields: [
        { bits: "31:0" }
      ],
    },
    { name: "Channel_Flags_c45",
      desc: "Defines wheter interrupts or polling is used for communication",
      swaccess: "rw",
      hwaccess: "none",
      fields: [
        { bits: "31:1" },
        { bits: "0",
          name: "intr_enable",
          desc: "If 1 interruts are used, if 0 polling is used"
        }
      ],
    },
    { name: "Length_c45",
      desc: "Lenght of payload + header",
      swaccess: "rw",
      hwaccess: "none",
      fields: [
        { bits: "31:0" }
      ],
    },
    { name: "Message_Header_c45",
      desc: "Defines which commanad the message contains",
      swaccess: "rw",
      hwaccess: "none",
      fields: [
        { bits: "31:28" },
        { bits: "27:18",
          name: "Token",
          desc: "must be same for the msg responses associated to a msg whith the same header"
        },
        { bits: "17:10",
          name: "Protocol_Id",
          desc: "Identifies to which protocol the command belongs to"
        },
        { bits: "9:8",
          name: "Message_Type",
          desc: "can be 0,1,2,3 depending on the kind of msg to be sent"
        },
        { bits: "7:0",
          name: "Message_Id",
          desc: "unique identifier for each command availabe in the protocol pointed by protocol_id"
        }
      ],
    },
    { name: "Message_Payload_1_c45",
      desc: "memory region dedicated to the parameters of the commands and their returns",
      swaccess: "rw",
      hwaccess: "none",
      fields: [
        { bits: "31:0" }
      ],
    },
    { name: "Doorbell_c45",
      desc: "Rapresents the interrupt to be raised towards the platform",
      swaccess: "rw",
      hwaccess: "hro",
      fields: [
        { bits: "31:1",
          name: "Preserve_Mask",
          desc: "These bits must be constant to 0, not used with just one platform and one agent"
        },
        { bits: "0",
          name: "intr",
          desc: "Interrupt bit"
        }
      ],
    },
    { name:  "Completion_Interrupt_c45",
      desc: "Rapresent the interrupt the platform should raise when it finishes to execute the received command",
      swaccess: "rw",
      hwaccess: "hro",
      fields: [
        { bits: "31:1",
          name: "Preserve_Mask",
          desc: "These bits must be constant to 0, not used with just one platform and one agent"
        },
        { bits: "0",
          name: "intr",
          desc: "Interrupt bit"
        }
      ],
    },
    { name: "Reserved_1_c46",
      desc: "Reserved, must be 0",
      swaccess: "rw",
      hwaccess: "none",
      fields: [
        { bits: "31:0" }
      ],
    },
    { name: "Channel_Status_c46",
      desc: "Indicates which entity has access to the Shared Memory",
      swaccess: "rw",
      hwaccess: "none",
      fields: [
        { bits: "31:2" },
        { bits: "1",
          name: "channel_error",
          desc: "Must be 0 in absence of errors"
        },
        { bits: "0",
          name: "channel_free",
          desc: "If 1 the agent own the channel, if 0 the platform own the channel"
        }
      ],
    },
    { name: "Reserved_2_c46",
      desc: "Reserved, implementation defined (32 bits over 64)",
      swaccess: "rw",
      hwaccess: "none",
      fields: [
        { bits: "31:0" }
      ],
    },
    { name: "Reserved_3_c46",
      desc: "Reserved, implementation defined (32 bits over 64)",
      swaccess: "none",
      hwaccess: "none",
      fields: [
        { bits: "31:0" }
      ],
    },
    { name: "Channel_Flags_c46",
      desc: "Defines wheter interrupts or polling is used for communication",
      swaccess: "rw",
      hwaccess: "none",
      fields: [
        { bits: "31:1" },
        { bits: "0",
          name: "intr_enable",
          desc: "If 1 interruts are used, if 0 polling is used"
        }
      ],
    },
    { name: "Length_c46",
      desc: "Lenght of payload + header",
      swaccess: "rw",
      hwaccess: "none",
      fields: [
        { bits: "31:0" }
      ],
    },
    { name: "Message_Header_c46",
      desc: "Defines which commanad the message contains",
      swaccess: "rw",
      hwaccess: "none",
      fields: [
        { bits: "31:28" },
        { bits: "27:18",
          name: "Token",
          desc: "must be same for the msg responses associated to a msg whith the same header"
        },
        { bits: "17:10",
          name: "Protocol_Id",
          desc: "Identifies to which protocol the command belongs to"
        },
        { bits: "9:8",
          name: "Message_Type",
          desc: "can be 0,1,2,3 depending on the kind of msg to be sent"
        },
        { bits: "7:0",
          name: "Message_Id",
          desc: "unique identifier for each command availabe in the protocol pointed by protocol_id"
        }
      ],
    },
    { name: "Message_Payload_1_c46",
      desc: "memory region dedicated to the parameters of the commands and their returns",
      swaccess: "rw",
      hwaccess: "none",
      fields: [
        { bits: "31:0" }
      ],
    },
    { name: "Doorbell_c46",
      desc: "Rapresents the interrupt to be raised towards the platform",
      swaccess: "rw",
      hwaccess: "hro",
      fields: [
        { bits: "31:1",
          name: "Preserve_Mask",
          desc: "These bits must be constant to 0, not used with just one platform and one agent"
        },
        { bits: "0",
          name: "intr",
          desc: "Interrupt bit"
        }
      ],
    },
    { name:  "Completion_Interrupt_c46",
      desc: "Rapresent the interrupt the platform should raise when it finishes to execute the received command",
      swaccess: "rw",
      hwaccess: "hro",
      fields: [
        { bits: "31:1",
          name: "Preserve_Mask",
          desc: "These bits must be constant to 0, not used with just one platform and one agent"
        },
        { bits: "0",
          name: "intr",
          desc: "Interrupt bit"
        }
      ],
    },
    { name: "Reserved_1_c47",
      desc: "Reserved, must be 0",
      swaccess: "rw",
      hwaccess: "none",
      fields: [
        { bits: "31:0" }
      ],
    },
    { name: "Channel_Status_c47",
      desc: "Indicates which entity has access to the Shared Memory",
      swaccess: "rw",
      hwaccess: "none",
      fields: [
        { bits: "31:2" },
        { bits: "1",
          name: "channel_error",
          desc: "Must be 0 in absence of errors"
        },
        { bits: "0",
          name: "channel_free",
          desc: "If 1 the agent own the channel, if 0 the platform own the channel"
        }
      ],
    },
    { name: "Reserved_2_c47",
      desc: "Reserved, implementation defined (32 bits over 64)",
      swaccess: "rw",
      hwaccess: "none",
      fields: [
        { bits: "31:0" }
      ],
    },
    { name: "Reserved_3_c47",
      desc: "Reserved, implementation defined (32 bits over 64)",
      swaccess: "none",
      hwaccess: "none",
      fields: [
        { bits: "31:0" }
      ],
    },
    { name: "Channel_Flags_c47",
      desc: "Defines wheter interrupts or polling is used for communication",
      swaccess: "rw",
      hwaccess: "none",
      fields: [
        { bits: "31:1" },
        { bits: "0",
          name: "intr_enable",
          desc: "If 1 interruts are used, if 0 polling is used"
        }
      ],
    },
    { name: "Length_c47",
      desc: "Lenght of payload + header",
      swaccess: "rw",
      hwaccess: "none",
      fields: [
        { bits: "31:0" }
      ],
    },
    { name: "Message_Header_c47",
      desc: "Defines which commanad the message contains",
      swaccess: "rw",
      hwaccess: "none",
      fields: [
        { bits: "31:28" },
        { bits: "27:18",
          name: "Token",
          desc: "must be same for the msg responses associated to a msg whith the same header"
        },
        { bits: "17:10",
          name: "Protocol_Id",
          desc: "Identifies to which protocol the command belongs to"
        },
        { bits: "9:8",
          name: "Message_Type",
          desc: "can be 0,1,2,3 depending on the kind of msg to be sent"
        },
        { bits: "7:0",
          name: "Message_Id",
          desc: "unique identifier for each command availabe in the protocol pointed by protocol_id"
        }
      ],
    },
    { name: "Message_Payload_1_c47",
      desc: "memory region dedicated to the parameters of the commands and their returns",
      swaccess: "rw",
      hwaccess: "none",
      fields: [
        { bits: "31:0" }
      ],
    },
    { name: "Doorbell_c47",
      desc: "Rapresents the interrupt to be raised towards the platform",
      swaccess: "rw",
      hwaccess: "hro",
      fields: [
        { bits: "31:1",
          name: "Preserve_Mask",
          desc: "These bits must be constant to 0, not used with just one platform and one agent"
        },
        { bits: "0",
          name: "intr",
          desc: "Interrupt bit"
        }
      ],
    },
    { name:  "Completion_Interrupt_c47",
      desc: "Rapresent the interrupt the platform should raise when it finishes to execute the received command",
      swaccess: "rw",
      hwaccess: "hro",
      fields: [
        { bits: "31:1",
          name: "Preserve_Mask",
          desc: "These bits must be constant to 0, not used with just one platform and one agent"
        },
        { bits: "0",
          name: "intr",
          desc: "Interrupt bit"
        }
      ],
    },
    { name: "Reserved_1_c48",
      desc: "Reserved, must be 0",
      swaccess: "rw",
      hwaccess: "none",
      fields: [
        { bits: "31:0" }
      ],
    },
    { name: "Channel_Status_c48",
      desc: "Indicates which entity has access to the Shared Memory",
      swaccess: "rw",
      hwaccess: "none",
      fields: [
        { bits: "31:2" },
        { bits: "1",
          name: "channel_error",
          desc: "Must be 0 in absence of errors"
        },
        { bits: "0",
          name: "channel_free",
          desc: "If 1 the agent own the channel, if 0 the platform own the channel"
        }
      ],
    },
    { name: "Reserved_2_c48",
      desc: "Reserved, implementation defined (32 bits over 64)",
      swaccess: "rw",
      hwaccess: "none",
      fields: [
        { bits: "31:0" }
      ],
    },
    { name: "Reserved_3_c48",
      desc: "Reserved, implementation defined (32 bits over 64)",
      swaccess: "none",
      hwaccess: "none",
      fields: [
        { bits: "31:0" }
      ],
    },
    { name: "Channel_Flags_c48",
      desc: "Defines wheter interrupts or polling is used for communication",
      swaccess: "rw",
      hwaccess: "none",
      fields: [
        { bits: "31:1" },
        { bits: "0",
          name: "intr_enable",
          desc: "If 1 interruts are used, if 0 polling is used"
        }
      ],
    },
    { name: "Length_c48",
      desc: "Lenght of payload + header",
      swaccess: "rw",
      hwaccess: "none",
      fields: [
        { bits: "31:0" }
      ],
    },
    { name: "Message_Header_c48",
      desc: "Defines which commanad the message contains",
      swaccess: "rw",
      hwaccess: "none",
      fields: [
        { bits: "31:28" },
        { bits: "27:18",
          name: "Token",
          desc: "must be same for the msg responses associated to a msg whith the same header"
        },
        { bits: "17:10",
          name: "Protocol_Id",
          desc: "Identifies to which protocol the command belongs to"
        },
        { bits: "9:8",
          name: "Message_Type",
          desc: "can be 0,1,2,3 depending on the kind of msg to be sent"
        },
        { bits: "7:0",
          name: "Message_Id",
          desc: "unique identifier for each command availabe in the protocol pointed by protocol_id"
        }
      ],
    },
    { name: "Message_Payload_1_c48",
      desc: "memory region dedicated to the parameters of the commands and their returns",
      swaccess: "rw",
      hwaccess: "none",
      fields: [
        { bits: "31:0" }
      ],
    },
    { name: "Doorbell_c48",
      desc: "Rapresents the interrupt to be raised towards the platform",
      swaccess: "rw",
      hwaccess: "hro",
      fields: [
        { bits: "31:1",
          name: "Preserve_Mask",
          desc: "These bits must be constant to 0, not used with just one platform and one agent"
        },
        { bits: "0",
          name: "intr",
          desc: "Interrupt bit"
        }
      ],
    },
    { name:  "Completion_Interrupt_c48",
      desc: "Rapresent the interrupt the platform should raise when it finishes to execute the received command",
      swaccess: "rw",
      hwaccess: "hro",
      fields: [
        { bits: "31:1",
          name: "Preserve_Mask",
          desc: "These bits must be constant to 0, not used with just one platform and one agent"
        },
        { bits: "0",
          name: "intr",
          desc: "Interrupt bit"
        }
      ],
    },
    { name: "Reserved_1_c49",
      desc: "Reserved, must be 0",
      swaccess: "rw",
      hwaccess: "none",
      fields: [
        { bits: "31:0" }
      ],
    },
    { name: "Channel_Status_c49",
      desc: "Indicates which entity has access to the Shared Memory",
      swaccess: "rw",
      hwaccess: "none",
      fields: [
        { bits: "31:2" },
        { bits: "1",
          name: "channel_error",
          desc: "Must be 0 in absence of errors"
        },
        { bits: "0",
          name: "channel_free",
          desc: "If 1 the agent own the channel, if 0 the platform own the channel"
        }
      ],
    },
    { name: "Reserved_2_c49",
      desc: "Reserved, implementation defined (32 bits over 64)",
      swaccess: "rw",
      hwaccess: "none",
      fields: [
        { bits: "31:0" }
      ],
    },
    { name: "Reserved_3_c49",
      desc: "Reserved, implementation defined (32 bits over 64)",
      swaccess: "none",
      hwaccess: "none",
      fields: [
        { bits: "31:0" }
      ],
    },
    { name: "Channel_Flags_c49",
      desc: "Defines wheter interrupts or polling is used for communication",
      swaccess: "rw",
      hwaccess: "none",
      fields: [
        { bits: "31:1" },
        { bits: "0",
          name: "intr_enable",
          desc: "If 1 interruts are used, if 0 polling is used"
        }
      ],
    },
    { name: "Length_c49",
      desc: "Lenght of payload + header",
      swaccess: "rw",
      hwaccess: "none",
      fields: [
        { bits: "31:0" }
      ],
    },
    { name: "Message_Header_c49",
      desc: "Defines which commanad the message contains",
      swaccess: "rw",
      hwaccess: "none",
      fields: [
        { bits: "31:28" },
        { bits: "27:18",
          name: "Token",
          desc: "must be same for the msg responses associated to a msg whith the same header"
        },
        { bits: "17:10",
          name: "Protocol_Id",
          desc: "Identifies to which protocol the command belongs to"
        },
        { bits: "9:8",
          name: "Message_Type",
          desc: "can be 0,1,2,3 depending on the kind of msg to be sent"
        },
        { bits: "7:0",
          name: "Message_Id",
          desc: "unique identifier for each command availabe in the protocol pointed by protocol_id"
        }
      ],
    },
    { name: "Message_Payload_1_c49",
      desc: "memory region dedicated to the parameters of the commands and their returns",
      swaccess: "rw",
      hwaccess: "none",
      fields: [
        { bits: "31:0" }
      ],
    },
    { name: "Doorbell_c49",
      desc: "Rapresents the interrupt to be raised towards the platform",
      swaccess: "rw",
      hwaccess: "hro",
      fields: [
        { bits: "31:1",
          name: "Preserve_Mask",
          desc: "These bits must be constant to 0, not used with just one platform and one agent"
        },
        { bits: "0",
          name: "intr",
          desc: "Interrupt bit"
        }
      ],
    },
    { name:  "Completion_Interrupt_c49",
      desc: "Rapresent the interrupt the platform should raise when it finishes to execute the received command",
      swaccess: "rw",
      hwaccess: "hro",
      fields: [
        { bits: "31:1",
          name: "Preserve_Mask",
          desc: "These bits must be constant to 0, not used with just one platform and one agent"
        },
        { bits: "0",
          name: "intr",
          desc: "Interrupt bit"
        }
      ],
    },
    { name: "Reserved_1_c50",
      desc: "Reserved, must be 0",
      swaccess: "rw",
      hwaccess: "none",
      fields: [
        { bits: "31:0" }
      ],
    },
    { name: "Channel_Status_c50",
      desc: "Indicates which entity has access to the Shared Memory",
      swaccess: "rw",
      hwaccess: "none",
      fields: [
        { bits: "31:2" },
        { bits: "1",
          name: "channel_error",
          desc: "Must be 0 in absence of errors"
        },
        { bits: "0",
          name: "channel_free",
          desc: "If 1 the agent own the channel, if 0 the platform own the channel"
        }
      ],
    },
    { name: "Reserved_2_c50",
      desc: "Reserved, implementation defined (32 bits over 64)",
      swaccess: "rw",
      hwaccess: "none",
      fields: [
        { bits: "31:0" }
      ],
    },
    { name: "Reserved_3_c50",
      desc: "Reserved, implementation defined (32 bits over 64)",
      swaccess: "none",
      hwaccess: "none",
      fields: [
        { bits: "31:0" }
      ],
    },
    { name: "Channel_Flags_c50",
      desc: "Defines wheter interrupts or polling is used for communication",
      swaccess: "rw",
      hwaccess: "none",
      fields: [
        { bits: "31:1" },
        { bits: "0",
          name: "intr_enable",
          desc: "If 1 interruts are used, if 0 polling is used"
        }
      ],
    },
    { name: "Length_c50",
      desc: "Lenght of payload + header",
      swaccess: "rw",
      hwaccess: "none",
      fields: [
        { bits: "31:0" }
      ],
    },
    { name: "Message_Header_c50",
      desc: "Defines which commanad the message contains",
      swaccess: "rw",
      hwaccess: "none",
      fields: [
        { bits: "31:28" },
        { bits: "27:18",
          name: "Token",
          desc: "must be same for the msg responses associated to a msg whith the same header"
        },
        { bits: "17:10",
          name: "Protocol_Id",
          desc: "Identifies to which protocol the command belongs to"
        },
        { bits: "9:8",
          name: "Message_Type",
          desc: "can be 0,1,2,3 depending on the kind of msg to be sent"
        },
        { bits: "7:0",
          name: "Message_Id",
          desc: "unique identifier for each command availabe in the protocol pointed by protocol_id"
        }
      ],
    },
    { name: "Message_Payload_1_c50",
      desc: "memory region dedicated to the parameters of the commands and their returns",
      swaccess: "rw",
      hwaccess: "none",
      fields: [
        { bits: "31:0" }
      ],
    },
    { name: "Doorbell_c50",
      desc: "Rapresents the interrupt to be raised towards the platform",
      swaccess: "rw",
      hwaccess: "hro",
      fields: [
        { bits: "31:1",
          name: "Preserve_Mask",
          desc: "These bits must be constant to 0, not used with just one platform and one agent"
        },
        { bits: "0",
          name: "intr",
          desc: "Interrupt bit"
        }
      ],
    },
    { name:  "Completion_Interrupt_c50",
      desc: "Rapresent the interrupt the platform should raise when it finishes to execute the received command",
      swaccess: "rw",
      hwaccess: "hro",
      fields: [
        { bits: "31:1",
          name: "Preserve_Mask",
          desc: "These bits must be constant to 0, not used with just one platform and one agent"
        },
        { bits: "0",
          name: "intr",
          desc: "Interrupt bit"
        }
      ],
    },
    { name: "Reserved_1_c51",
      desc: "Reserved, must be 0",
      swaccess: "rw",
      hwaccess: "none",
      fields: [
        { bits: "31:0" }
      ],
    },
    { name: "Channel_Status_c51",
      desc: "Indicates which entity has access to the Shared Memory",
      swaccess: "rw",
      hwaccess: "none",
      fields: [
        { bits: "31:2" },
        { bits: "1",
          name: "channel_error",
          desc: "Must be 0 in absence of errors"
        },
        { bits: "0",
          name: "channel_free",
          desc: "If 1 the agent own the channel, if 0 the platform own the channel"
        }
      ],
    },
    { name: "Reserved_2_c51",
      desc: "Reserved, implementation defined (32 bits over 64)",
      swaccess: "rw",
      hwaccess: "none",
      fields: [
        { bits: "31:0" }
      ],
    },
    { name: "Reserved_3_c51",
      desc: "Reserved, implementation defined (32 bits over 64)",
      swaccess: "none",
      hwaccess: "none",
      fields: [
        { bits: "31:0" }
      ],
    },
    { name: "Channel_Flags_c51",
      desc: "Defines wheter interrupts or polling is used for communication",
      swaccess: "rw",
      hwaccess: "none",
      fields: [
        { bits: "31:1" },
        { bits: "0",
          name: "intr_enable",
          desc: "If 1 interruts are used, if 0 polling is used"
        }
      ],
    },
    { name: "Length_c51",
      desc: "Lenght of payload + header",
      swaccess: "rw",
      hwaccess: "none",
      fields: [
        { bits: "31:0" }
      ],
    },
    { name: "Message_Header_c51",
      desc: "Defines which commanad the message contains",
      swaccess: "rw",
      hwaccess: "none",
      fields: [
        { bits: "31:28" },
        { bits: "27:18",
          name: "Token",
          desc: "must be same for the msg responses associated to a msg whith the same header"
        },
        { bits: "17:10",
          name: "Protocol_Id",
          desc: "Identifies to which protocol the command belongs to"
        },
        { bits: "9:8",
          name: "Message_Type",
          desc: "can be 0,1,2,3 depending on the kind of msg to be sent"
        },
        { bits: "7:0",
          name: "Message_Id",
          desc: "unique identifier for each command availabe in the protocol pointed by protocol_id"
        }
      ],
    },
    { name: "Message_Payload_1_c51",
      desc: "memory region dedicated to the parameters of the commands and their returns",
      swaccess: "rw",
      hwaccess: "none",
      fields: [
        { bits: "31:0" }
      ],
    },
    { name: "Doorbell_c51",
      desc: "Rapresents the interrupt to be raised towards the platform",
      swaccess: "rw",
      hwaccess: "hro",
      fields: [
        { bits: "31:1",
          name: "Preserve_Mask",
          desc: "These bits must be constant to 0, not used with just one platform and one agent"
        },
        { bits: "0",
          name: "intr",
          desc: "Interrupt bit"
        }
      ],
    },
    { name:  "Completion_Interrupt_c51",
      desc: "Rapresent the interrupt the platform should raise when it finishes to execute the received command",
      swaccess: "rw",
      hwaccess: "hro",
      fields: [
        { bits: "31:1",
          name: "Preserve_Mask",
          desc: "These bits must be constant to 0, not used with just one platform and one agent"
        },
        { bits: "0",
          name: "intr",
          desc: "Interrupt bit"
        }
      ],
    },
    { name: "Reserved_1_c52",
      desc: "Reserved, must be 0",
      swaccess: "rw",
      hwaccess: "none",
      fields: [
        { bits: "31:0" }
      ],
    },
    { name: "Channel_Status_c52",
      desc: "Indicates which entity has access to the Shared Memory",
      swaccess: "rw",
      hwaccess: "none",
      fields: [
        { bits: "31:2" },
        { bits: "1",
          name: "channel_error",
          desc: "Must be 0 in absence of errors"
        },
        { bits: "0",
          name: "channel_free",
          desc: "If 1 the agent own the channel, if 0 the platform own the channel"
        }
      ],
    },
    { name: "Reserved_2_c52",
      desc: "Reserved, implementation defined (32 bits over 64)",
      swaccess: "rw",
      hwaccess: "none",
      fields: [
        { bits: "31:0" }
      ],
    },
    { name: "Reserved_3_c52",
      desc: "Reserved, implementation defined (32 bits over 64)",
      swaccess: "none",
      hwaccess: "none",
      fields: [
        { bits: "31:0" }
      ],
    },
    { name: "Channel_Flags_c52",
      desc: "Defines wheter interrupts or polling is used for communication",
      swaccess: "rw",
      hwaccess: "none",
      fields: [
        { bits: "31:1" },
        { bits: "0",
          name: "intr_enable",
          desc: "If 1 interruts are used, if 0 polling is used"
        }
      ],
    },
    { name: "Length_c52",
      desc: "Lenght of payload + header",
      swaccess: "rw",
      hwaccess: "none",
      fields: [
        { bits: "31:0" }
      ],
    },
    { name: "Message_Header_c52",
      desc: "Defines which commanad the message contains",
      swaccess: "rw",
      hwaccess: "none",
      fields: [
        { bits: "31:28" },
        { bits: "27:18",
          name: "Token",
          desc: "must be same for the msg responses associated to a msg whith the same header"
        },
        { bits: "17:10",
          name: "Protocol_Id",
          desc: "Identifies to which protocol the command belongs to"
        },
        { bits: "9:8",
          name: "Message_Type",
          desc: "can be 0,1,2,3 depending on the kind of msg to be sent"
        },
        { bits: "7:0",
          name: "Message_Id",
          desc: "unique identifier for each command availabe in the protocol pointed by protocol_id"
        }
      ],
    },
    { name: "Message_Payload_1_c52",
      desc: "memory region dedicated to the parameters of the commands and their returns",
      swaccess: "rw",
      hwaccess: "none",
      fields: [
        { bits: "31:0" }
      ],
    },
    { name: "Doorbell_c52",
      desc: "Rapresents the interrupt to be raised towards the platform",
      swaccess: "rw",
      hwaccess: "hro",
      fields: [
        { bits: "31:1",
          name: "Preserve_Mask",
          desc: "These bits must be constant to 0, not used with just one platform and one agent"
        },
        { bits: "0",
          name: "intr",
          desc: "Interrupt bit"
        }
      ],
    },
    { name:  "Completion_Interrupt_c52",
      desc: "Rapresent the interrupt the platform should raise when it finishes to execute the received command",
      swaccess: "rw",
      hwaccess: "hro",
      fields: [
        { bits: "31:1",
          name: "Preserve_Mask",
          desc: "These bits must be constant to 0, not used with just one platform and one agent"
        },
        { bits: "0",
          name: "intr",
          desc: "Interrupt bit"
        }
      ],
    },
    { name: "Reserved_1_c53",
      desc: "Reserved, must be 0",
      swaccess: "rw",
      hwaccess: "none",
      fields: [
        { bits: "31:0" }
      ],
    },
    { name: "Channel_Status_c53",
      desc: "Indicates which entity has access to the Shared Memory",
      swaccess: "rw",
      hwaccess: "none",
      fields: [
        { bits: "31:2" },
        { bits: "1",
          name: "channel_error",
          desc: "Must be 0 in absence of errors"
        },
        { bits: "0",
          name: "channel_free",
          desc: "If 1 the agent own the channel, if 0 the platform own the channel"
        }
      ],
    },
    { name: "Reserved_2_c53",
      desc: "Reserved, implementation defined (32 bits over 64)",
      swaccess: "rw",
      hwaccess: "none",
      fields: [
        { bits: "31:0" }
      ],
    },
    { name: "Reserved_3_c53",
      desc: "Reserved, implementation defined (32 bits over 64)",
      swaccess: "none",
      hwaccess: "none",
      fields: [
        { bits: "31:0" }
      ],
    },
    { name: "Channel_Flags_c53",
      desc: "Defines wheter interrupts or polling is used for communication",
      swaccess: "rw",
      hwaccess: "none",
      fields: [
        { bits: "31:1" },
        { bits: "0",
          name: "intr_enable",
          desc: "If 1 interruts are used, if 0 polling is used"
        }
      ],
    },
    { name: "Length_c53",
      desc: "Lenght of payload + header",
      swaccess: "rw",
      hwaccess: "none",
      fields: [
        { bits: "31:0" }
      ],
    },
    { name: "Message_Header_c53",
      desc: "Defines which commanad the message contains",
      swaccess: "rw",
      hwaccess: "none",
      fields: [
        { bits: "31:28" },
        { bits: "27:18",
          name: "Token",
          desc: "must be same for the msg responses associated to a msg whith the same header"
        },
        { bits: "17:10",
          name: "Protocol_Id",
          desc: "Identifies to which protocol the command belongs to"
        },
        { bits: "9:8",
          name: "Message_Type",
          desc: "can be 0,1,2,3 depending on the kind of msg to be sent"
        },
        { bits: "7:0",
          name: "Message_Id",
          desc: "unique identifier for each command availabe in the protocol pointed by protocol_id"
        }
      ],
    },
    { name: "Message_Payload_1_c53",
      desc: "memory region dedicated to the parameters of the commands and their returns",
      swaccess: "rw",
      hwaccess: "none",
      fields: [
        { bits: "31:0" }
      ],
    },
    { name: "Doorbell_c53",
      desc: "Rapresents the interrupt to be raised towards the platform",
      swaccess: "rw",
      hwaccess: "hro",
      fields: [
        { bits: "31:1",
          name: "Preserve_Mask",
          desc: "These bits must be constant to 0, not used with just one platform and one agent"
        },
        { bits: "0",
          name: "intr",
          desc: "Interrupt bit"
        }
      ],
    },
    { name:  "Completion_Interrupt_c53",
      desc: "Rapresent the interrupt the platform should raise when it finishes to execute the received command",
      swaccess: "rw",
      hwaccess: "hro",
      fields: [
        { bits: "31:1",
          name: "Preserve_Mask",
          desc: "These bits must be constant to 0, not used with just one platform and one agent"
        },
        { bits: "0",
          name: "intr",
          desc: "Interrupt bit"
        }
      ],
    },
    { name: "Reserved_1_c54",
      desc: "Reserved, must be 0",
      swaccess: "rw",
      hwaccess: "none",
      fields: [
        { bits: "31:0" }
      ],
    },
    { name: "Channel_Status_c54",
      desc: "Indicates which entity has access to the Shared Memory",
      swaccess: "rw",
      hwaccess: "none",
      fields: [
        { bits: "31:2" },
        { bits: "1",
          name: "channel_error",
          desc: "Must be 0 in absence of errors"
        },
        { bits: "0",
          name: "channel_free",
          desc: "If 1 the agent own the channel, if 0 the platform own the channel"
        }
      ],
    },
    { name: "Reserved_2_c54",
      desc: "Reserved, implementation defined (32 bits over 64)",
      swaccess: "rw",
      hwaccess: "none",
      fields: [
        { bits: "31:0" }
      ],
    },
    { name: "Reserved_3_c54",
      desc: "Reserved, implementation defined (32 bits over 64)",
      swaccess: "none",
      hwaccess: "none",
      fields: [
        { bits: "31:0" }
      ],
    },
    { name: "Channel_Flags_c54",
      desc: "Defines wheter interrupts or polling is used for communication",
      swaccess: "rw",
      hwaccess: "none",
      fields: [
        { bits: "31:1" },
        { bits: "0",
          name: "intr_enable",
          desc: "If 1 interruts are used, if 0 polling is used"
        }
      ],
    },
    { name: "Length_c54",
      desc: "Lenght of payload + header",
      swaccess: "rw",
      hwaccess: "none",
      fields: [
        { bits: "31:0" }
      ],
    },
    { name: "Message_Header_c54",
      desc: "Defines which commanad the message contains",
      swaccess: "rw",
      hwaccess: "none",
      fields: [
        { bits: "31:28" },
        { bits: "27:18",
          name: "Token",
          desc: "must be same for the msg responses associated to a msg whith the same header"
        },
        { bits: "17:10",
          name: "Protocol_Id",
          desc: "Identifies to which protocol the command belongs to"
        },
        { bits: "9:8",
          name: "Message_Type",
          desc: "can be 0,1,2,3 depending on the kind of msg to be sent"
        },
        { bits: "7:0",
          name: "Message_Id",
          desc: "unique identifier for each command availabe in the protocol pointed by protocol_id"
        }
      ],
    },
    { name: "Message_Payload_1_c54",
      desc: "memory region dedicated to the parameters of the commands and their returns",
      swaccess: "rw",
      hwaccess: "none",
      fields: [
        { bits: "31:0" }
      ],
    },
    { name: "Doorbell_c54",
      desc: "Rapresents the interrupt to be raised towards the platform",
      swaccess: "rw",
      hwaccess: "hro",
      fields: [
        { bits: "31:1",
          name: "Preserve_Mask",
          desc: "These bits must be constant to 0, not used with just one platform and one agent"
        },
        { bits: "0",
          name: "intr",
          desc: "Interrupt bit"
        }
      ],
    },
    { name:  "Completion_Interrupt_c54",
      desc: "Rapresent the interrupt the platform should raise when it finishes to execute the received command",
      swaccess: "rw",
      hwaccess: "hro",
      fields: [
        { bits: "31:1",
          name: "Preserve_Mask",
          desc: "These bits must be constant to 0, not used with just one platform and one agent"
        },
        { bits: "0",
          name: "intr",
          desc: "Interrupt bit"
        }
      ],
    },
    { name: "Reserved_1_c55",
      desc: "Reserved, must be 0",
      swaccess: "rw",
      hwaccess: "none",
      fields: [
        { bits: "31:0" }
      ],
    },
    { name: "Channel_Status_c55",
      desc: "Indicates which entity has access to the Shared Memory",
      swaccess: "rw",
      hwaccess: "none",
      fields: [
        { bits: "31:2" },
        { bits: "1",
          name: "channel_error",
          desc: "Must be 0 in absence of errors"
        },
        { bits: "0",
          name: "channel_free",
          desc: "If 1 the agent own the channel, if 0 the platform own the channel"
        }
      ],
    },
    { name: "Reserved_2_c55",
      desc: "Reserved, implementation defined (32 bits over 64)",
      swaccess: "rw",
      hwaccess: "none",
      fields: [
        { bits: "31:0" }
      ],
    },
    { name: "Reserved_3_c55",
      desc: "Reserved, implementation defined (32 bits over 64)",
      swaccess: "none",
      hwaccess: "none",
      fields: [
        { bits: "31:0" }
      ],
    },
    { name: "Channel_Flags_c55",
      desc: "Defines wheter interrupts or polling is used for communication",
      swaccess: "rw",
      hwaccess: "none",
      fields: [
        { bits: "31:1" },
        { bits: "0",
          name: "intr_enable",
          desc: "If 1 interruts are used, if 0 polling is used"
        }
      ],
    },
    { name: "Length_c55",
      desc: "Lenght of payload + header",
      swaccess: "rw",
      hwaccess: "none",
      fields: [
        { bits: "31:0" }
      ],
    },
    { name: "Message_Header_c55",
      desc: "Defines which commanad the message contains",
      swaccess: "rw",
      hwaccess: "none",
      fields: [
        { bits: "31:28" },
        { bits: "27:18",
          name: "Token",
          desc: "must be same for the msg responses associated to a msg whith the same header"
        },
        { bits: "17:10",
          name: "Protocol_Id",
          desc: "Identifies to which protocol the command belongs to"
        },
        { bits: "9:8",
          name: "Message_Type",
          desc: "can be 0,1,2,3 depending on the kind of msg to be sent"
        },
        { bits: "7:0",
          name: "Message_Id",
          desc: "unique identifier for each command availabe in the protocol pointed by protocol_id"
        }
      ],
    },
    { name: "Message_Payload_1_c55",
      desc: "memory region dedicated to the parameters of the commands and their returns",
      swaccess: "rw",
      hwaccess: "none",
      fields: [
        { bits: "31:0" }
      ],
    },
    { name: "Doorbell_c55",
      desc: "Rapresents the interrupt to be raised towards the platform",
      swaccess: "rw",
      hwaccess: "hro",
      fields: [
        { bits: "31:1",
          name: "Preserve_Mask",
          desc: "These bits must be constant to 0, not used with just one platform and one agent"
        },
        { bits: "0",
          name: "intr",
          desc: "Interrupt bit"
        }
      ],
    },
    { name:  "Completion_Interrupt_c55",
      desc: "Rapresent the interrupt the platform should raise when it finishes to execute the received command",
      swaccess: "rw",
      hwaccess: "hro",
      fields: [
        { bits: "31:1",
          name: "Preserve_Mask",
          desc: "These bits must be constant to 0, not used with just one platform and one agent"
        },
        { bits: "0",
          name: "intr",
          desc: "Interrupt bit"
        }
      ],
    },
    { name: "Reserved_1_c56",
      desc: "Reserved, must be 0",
      swaccess: "rw",
      hwaccess: "none",
      fields: [
        { bits: "31:0" }
      ],
    },
    { name: "Channel_Status_c56",
      desc: "Indicates which entity has access to the Shared Memory",
      swaccess: "rw",
      hwaccess: "none",
      fields: [
        { bits: "31:2" },
        { bits: "1",
          name: "channel_error",
          desc: "Must be 0 in absence of errors"
        },
        { bits: "0",
          name: "channel_free",
          desc: "If 1 the agent own the channel, if 0 the platform own the channel"
        }
      ],
    },
    { name: "Reserved_2_c56",
      desc: "Reserved, implementation defined (32 bits over 64)",
      swaccess: "rw",
      hwaccess: "none",
      fields: [
        { bits: "31:0" }
      ],
    },
    { name: "Reserved_3_c56",
      desc: "Reserved, implementation defined (32 bits over 64)",
      swaccess: "none",
      hwaccess: "none",
      fields: [
        { bits: "31:0" }
      ],
    },
    { name: "Channel_Flags_c56",
      desc: "Defines wheter interrupts or polling is used for communication",
      swaccess: "rw",
      hwaccess: "none",
      fields: [
        { bits: "31:1" },
        { bits: "0",
          name: "intr_enable",
          desc: "If 1 interruts are used, if 0 polling is used"
        }
      ],
    },
    { name: "Length_c56",
      desc: "Lenght of payload + header",
      swaccess: "rw",
      hwaccess: "none",
      fields: [
        { bits: "31:0" }
      ],
    },
    { name: "Message_Header_c56",
      desc: "Defines which commanad the message contains",
      swaccess: "rw",
      hwaccess: "none",
      fields: [
        { bits: "31:28" },
        { bits: "27:18",
          name: "Token",
          desc: "must be same for the msg responses associated to a msg whith the same header"
        },
        { bits: "17:10",
          name: "Protocol_Id",
          desc: "Identifies to which protocol the command belongs to"
        },
        { bits: "9:8",
          name: "Message_Type",
          desc: "can be 0,1,2,3 depending on the kind of msg to be sent"
        },
        { bits: "7:0",
          name: "Message_Id",
          desc: "unique identifier for each command availabe in the protocol pointed by protocol_id"
        }
      ],
    },
    { name: "Message_Payload_1_c56",
      desc: "memory region dedicated to the parameters of the commands and their returns",
      swaccess: "rw",
      hwaccess: "none",
      fields: [
        { bits: "31:0" }
      ],
    },
    { name: "Doorbell_c56",
      desc: "Rapresents the interrupt to be raised towards the platform",
      swaccess: "rw",
      hwaccess: "hro",
      fields: [
        { bits: "31:1",
          name: "Preserve_Mask",
          desc: "These bits must be constant to 0, not used with just one platform and one agent"
        },
        { bits: "0",
          name: "intr",
          desc: "Interrupt bit"
        }
      ],
    },
    { name:  "Completion_Interrupt_c56",
      desc: "Rapresent the interrupt the platform should raise when it finishes to execute the received command",
      swaccess: "rw",
      hwaccess: "hro",
      fields: [
        { bits: "31:1",
          name: "Preserve_Mask",
          desc: "These bits must be constant to 0, not used with just one platform and one agent"
        },
        { bits: "0",
          name: "intr",
          desc: "Interrupt bit"
        }
      ],
    },
    { name: "Reserved_1_c57",
      desc: "Reserved, must be 0",
      swaccess: "rw",
      hwaccess: "none",
      fields: [
        { bits: "31:0" }
      ],
    },
    { name: "Channel_Status_c57",
      desc: "Indicates which entity has access to the Shared Memory",
      swaccess: "rw",
      hwaccess: "none",
      fields: [
        { bits: "31:2" },
        { bits: "1",
          name: "channel_error",
          desc: "Must be 0 in absence of errors"
        },
        { bits: "0",
          name: "channel_free",
          desc: "If 1 the agent own the channel, if 0 the platform own the channel"
        }
      ],
    },
    { name: "Reserved_2_c57",
      desc: "Reserved, implementation defined (32 bits over 64)",
      swaccess: "rw",
      hwaccess: "none",
      fields: [
        { bits: "31:0" }
      ],
    },
    { name: "Reserved_3_c57",
      desc: "Reserved, implementation defined (32 bits over 64)",
      swaccess: "none",
      hwaccess: "none",
      fields: [
        { bits: "31:0" }
      ],
    },
    { name: "Channel_Flags_c57",
      desc: "Defines wheter interrupts or polling is used for communication",
      swaccess: "rw",
      hwaccess: "none",
      fields: [
        { bits: "31:1" },
        { bits: "0",
          name: "intr_enable",
          desc: "If 1 interruts are used, if 0 polling is used"
        }
      ],
    },
    { name: "Length_c57",
      desc: "Lenght of payload + header",
      swaccess: "rw",
      hwaccess: "none",
      fields: [
        { bits: "31:0" }
      ],
    },
    { name: "Message_Header_c57",
      desc: "Defines which commanad the message contains",
      swaccess: "rw",
      hwaccess: "none",
      fields: [
        { bits: "31:28" },
        { bits: "27:18",
          name: "Token",
          desc: "must be same for the msg responses associated to a msg whith the same header"
        },
        { bits: "17:10",
          name: "Protocol_Id",
          desc: "Identifies to which protocol the command belongs to"
        },
        { bits: "9:8",
          name: "Message_Type",
          desc: "can be 0,1,2,3 depending on the kind of msg to be sent"
        },
        { bits: "7:0",
          name: "Message_Id",
          desc: "unique identifier for each command availabe in the protocol pointed by protocol_id"
        }
      ],
    },
    { name: "Message_Payload_1_c57",
      desc: "memory region dedicated to the parameters of the commands and their returns",
      swaccess: "rw",
      hwaccess: "none",
      fields: [
        { bits: "31:0" }
      ],
    },
    { name: "Doorbell_c57",
      desc: "Rapresents the interrupt to be raised towards the platform",
      swaccess: "rw",
      hwaccess: "hro",
      fields: [
        { bits: "31:1",
          name: "Preserve_Mask",
          desc: "These bits must be constant to 0, not used with just one platform and one agent"
        },
        { bits: "0",
          name: "intr",
          desc: "Interrupt bit"
        }
      ],
    },
    { name:  "Completion_Interrupt_c57",
      desc: "Rapresent the interrupt the platform should raise when it finishes to execute the received command",
      swaccess: "rw",
      hwaccess: "hro",
      fields: [
        { bits: "31:1",
          name: "Preserve_Mask",
          desc: "These bits must be constant to 0, not used with just one platform and one agent"
        },
        { bits: "0",
          name: "intr",
          desc: "Interrupt bit"
        }
      ],
    },
    { name: "Reserved_1_c58",
      desc: "Reserved, must be 0",
      swaccess: "rw",
      hwaccess: "none",
      fields: [
        { bits: "31:0" }
      ],
    },
    { name: "Channel_Status_c58",
      desc: "Indicates which entity has access to the Shared Memory",
      swaccess: "rw",
      hwaccess: "none",
      fields: [
        { bits: "31:2" },
        { bits: "1",
          name: "channel_error",
          desc: "Must be 0 in absence of errors"
        },
        { bits: "0",
          name: "channel_free",
          desc: "If 1 the agent own the channel, if 0 the platform own the channel"
        }
      ],
    },
    { name: "Reserved_2_c58",
      desc: "Reserved, implementation defined (32 bits over 64)",
      swaccess: "rw",
      hwaccess: "none",
      fields: [
        { bits: "31:0" }
      ],
    },
    { name: "Reserved_3_c58",
      desc: "Reserved, implementation defined (32 bits over 64)",
      swaccess: "none",
      hwaccess: "none",
      fields: [
        { bits: "31:0" }
      ],
    },
    { name: "Channel_Flags_c58",
      desc: "Defines wheter interrupts or polling is used for communication",
      swaccess: "rw",
      hwaccess: "none",
      fields: [
        { bits: "31:1" },
        { bits: "0",
          name: "intr_enable",
          desc: "If 1 interruts are used, if 0 polling is used"
        }
      ],
    },
    { name: "Length_c58",
      desc: "Lenght of payload + header",
      swaccess: "rw",
      hwaccess: "none",
      fields: [
        { bits: "31:0" }
      ],
    },
    { name: "Message_Header_c58",
      desc: "Defines which commanad the message contains",
      swaccess: "rw",
      hwaccess: "none",
      fields: [
        { bits: "31:28" },
        { bits: "27:18",
          name: "Token",
          desc: "must be same for the msg responses associated to a msg whith the same header"
        },
        { bits: "17:10",
          name: "Protocol_Id",
          desc: "Identifies to which protocol the command belongs to"
        },
        { bits: "9:8",
          name: "Message_Type",
          desc: "can be 0,1,2,3 depending on the kind of msg to be sent"
        },
        { bits: "7:0",
          name: "Message_Id",
          desc: "unique identifier for each command availabe in the protocol pointed by protocol_id"
        }
      ],
    },
    { name: "Message_Payload_1_c58",
      desc: "memory region dedicated to the parameters of the commands and their returns",
      swaccess: "rw",
      hwaccess: "none",
      fields: [
        { bits: "31:0" }
      ],
    },
    { name: "Doorbell_c58",
      desc: "Rapresents the interrupt to be raised towards the platform",
      swaccess: "rw",
      hwaccess: "hro",
      fields: [
        { bits: "31:1",
          name: "Preserve_Mask",
          desc: "These bits must be constant to 0, not used with just one platform and one agent"
        },
        { bits: "0",
          name: "intr",
          desc: "Interrupt bit"
        }
      ],
    },
    { name:  "Completion_Interrupt_c58",
      desc: "Rapresent the interrupt the platform should raise when it finishes to execute the received command",
      swaccess: "rw",
      hwaccess: "hro",
      fields: [
        { bits: "31:1",
          name: "Preserve_Mask",
          desc: "These bits must be constant to 0, not used with just one platform and one agent"
        },
        { bits: "0",
          name: "intr",
          desc: "Interrupt bit"
        }
      ],
    },
    { name: "Reserved_1_c59",
      desc: "Reserved, must be 0",
      swaccess: "rw",
      hwaccess: "none",
      fields: [
        { bits: "31:0" }
      ],
    },
    { name: "Channel_Status_c59",
      desc: "Indicates which entity has access to the Shared Memory",
      swaccess: "rw",
      hwaccess: "none",
      fields: [
        { bits: "31:2" },
        { bits: "1",
          name: "channel_error",
          desc: "Must be 0 in absence of errors"
        },
        { bits: "0",
          name: "channel_free",
          desc: "If 1 the agent own the channel, if 0 the platform own the channel"
        }
      ],
    },
    { name: "Reserved_2_c59",
      desc: "Reserved, implementation defined (32 bits over 64)",
      swaccess: "rw",
      hwaccess: "none",
      fields: [
        { bits: "31:0" }
      ],
    },
    { name: "Reserved_3_c59",
      desc: "Reserved, implementation defined (32 bits over 64)",
      swaccess: "none",
      hwaccess: "none",
      fields: [
        { bits: "31:0" }
      ],
    },
    { name: "Channel_Flags_c59",
      desc: "Defines wheter interrupts or polling is used for communication",
      swaccess: "rw",
      hwaccess: "none",
      fields: [
        { bits: "31:1" },
        { bits: "0",
          name: "intr_enable",
          desc: "If 1 interruts are used, if 0 polling is used"
        }
      ],
    },
    { name: "Length_c59",
      desc: "Lenght of payload + header",
      swaccess: "rw",
      hwaccess: "none",
      fields: [
        { bits: "31:0" }
      ],
    },
    { name: "Message_Header_c59",
      desc: "Defines which commanad the message contains",
      swaccess: "rw",
      hwaccess: "none",
      fields: [
        { bits: "31:28" },
        { bits: "27:18",
          name: "Token",
          desc: "must be same for the msg responses associated to a msg whith the same header"
        },
        { bits: "17:10",
          name: "Protocol_Id",
          desc: "Identifies to which protocol the command belongs to"
        },
        { bits: "9:8",
          name: "Message_Type",
          desc: "can be 0,1,2,3 depending on the kind of msg to be sent"
        },
        { bits: "7:0",
          name: "Message_Id",
          desc: "unique identifier for each command availabe in the protocol pointed by protocol_id"
        }
      ],
    },
    { name: "Message_Payload_1_c59",
      desc: "memory region dedicated to the parameters of the commands and their returns",
      swaccess: "rw",
      hwaccess: "none",
      fields: [
        { bits: "31:0" }
      ],
    },
    { name: "Doorbell_c59",
      desc: "Rapresents the interrupt to be raised towards the platform",
      swaccess: "rw",
      hwaccess: "hro",
      fields: [
        { bits: "31:1",
          name: "Preserve_Mask",
          desc: "These bits must be constant to 0, not used with just one platform and one agent"
        },
        { bits: "0",
          name: "intr",
          desc: "Interrupt bit"
        }
      ],
    },
    { name:  "Completion_Interrupt_c59",
      desc: "Rapresent the interrupt the platform should raise when it finishes to execute the received command",
      swaccess: "rw",
      hwaccess: "hro",
      fields: [
        { bits: "31:1",
          name: "Preserve_Mask",
          desc: "These bits must be constant to 0, not used with just one platform and one agent"
        },
        { bits: "0",
          name: "intr",
          desc: "Interrupt bit"
        }
      ],
    },
    { name: "Reserved_1_c60",
      desc: "Reserved, must be 0",
      swaccess: "rw",
      hwaccess: "none",
      fields: [
        { bits: "31:0" }
      ],
    },
    { name: "Channel_Status_c60",
      desc: "Indicates which entity has access to the Shared Memory",
      swaccess: "rw",
      hwaccess: "none",
      fields: [
        { bits: "31:2" },
        { bits: "1",
          name: "channel_error",
          desc: "Must be 0 in absence of errors"
        },
        { bits: "0",
          name: "channel_free",
          desc: "If 1 the agent own the channel, if 0 the platform own the channel"
        }
      ],
    },
    { name: "Reserved_2_c60",
      desc: "Reserved, implementation defined (32 bits over 64)",
      swaccess: "rw",
      hwaccess: "none",
      fields: [
        { bits: "31:0" }
      ],
    },
    { name: "Reserved_3_c60",
      desc: "Reserved, implementation defined (32 bits over 64)",
      swaccess: "none",
      hwaccess: "none",
      fields: [
        { bits: "31:0" }
      ],
    },
    { name: "Channel_Flags_c60",
      desc: "Defines wheter interrupts or polling is used for communication",
      swaccess: "rw",
      hwaccess: "none",
      fields: [
        { bits: "31:1" },
        { bits: "0",
          name: "intr_enable",
          desc: "If 1 interruts are used, if 0 polling is used"
        }
      ],
    },
    { name: "Length_c60",
      desc: "Lenght of payload + header",
      swaccess: "rw",
      hwaccess: "none",
      fields: [
        { bits: "31:0" }
      ],
    },
    { name: "Message_Header_c60",
      desc: "Defines which commanad the message contains",
      swaccess: "rw",
      hwaccess: "none",
      fields: [
        { bits: "31:28" },
        { bits: "27:18",
          name: "Token",
          desc: "must be same for the msg responses associated to a msg whith the same header"
        },
        { bits: "17:10",
          name: "Protocol_Id",
          desc: "Identifies to which protocol the command belongs to"
        },
        { bits: "9:8",
          name: "Message_Type",
          desc: "can be 0,1,2,3 depending on the kind of msg to be sent"
        },
        { bits: "7:0",
          name: "Message_Id",
          desc: "unique identifier for each command availabe in the protocol pointed by protocol_id"
        }
      ],
    },
    { name: "Message_Payload_1_c60",
      desc: "memory region dedicated to the parameters of the commands and their returns",
      swaccess: "rw",
      hwaccess: "none",
      fields: [
        { bits: "31:0" }
      ],
    },
    { name: "Doorbell_c60",
      desc: "Rapresents the interrupt to be raised towards the platform",
      swaccess: "rw",
      hwaccess: "hro",
      fields: [
        { bits: "31:1",
          name: "Preserve_Mask",
          desc: "These bits must be constant to 0, not used with just one platform and one agent"
        },
        { bits: "0",
          name: "intr",
          desc: "Interrupt bit"
        }
      ],
    },
    { name:  "Completion_Interrupt_c60",
      desc: "Rapresent the interrupt the platform should raise when it finishes to execute the received command",
      swaccess: "rw",
      hwaccess: "hro",
      fields: [
        { bits: "31:1",
          name: "Preserve_Mask",
          desc: "These bits must be constant to 0, not used with just one platform and one agent"
        },
        { bits: "0",
          name: "intr",
          desc: "Interrupt bit"
        }
      ],
    },
    { name: "Reserved_1_c61",
      desc: "Reserved, must be 0",
      swaccess: "rw",
      hwaccess: "none",
      fields: [
        { bits: "31:0" }
      ],
    },
    { name: "Channel_Status_c61",
      desc: "Indicates which entity has access to the Shared Memory",
      swaccess: "rw",
      hwaccess: "none",
      fields: [
        { bits: "31:2" },
        { bits: "1",
          name: "channel_error",
          desc: "Must be 0 in absence of errors"
        },
        { bits: "0",
          name: "channel_free",
          desc: "If 1 the agent own the channel, if 0 the platform own the channel"
        }
      ],
    },
    { name: "Reserved_2_c61",
      desc: "Reserved, implementation defined (32 bits over 64)",
      swaccess: "rw",
      hwaccess: "none",
      fields: [
        { bits: "31:0" }
      ],
    },
    { name: "Reserved_3_c61",
      desc: "Reserved, implementation defined (32 bits over 64)",
      swaccess: "none",
      hwaccess: "none",
      fields: [
        { bits: "31:0" }
      ],
    },
    { name: "Channel_Flags_c61",
      desc: "Defines wheter interrupts or polling is used for communication",
      swaccess: "rw",
      hwaccess: "none",
      fields: [
        { bits: "31:1" },
        { bits: "0",
          name: "intr_enable",
          desc: "If 1 interruts are used, if 0 polling is used"
        }
      ],
    },
    { name: "Length_c61",
      desc: "Lenght of payload + header",
      swaccess: "rw",
      hwaccess: "none",
      fields: [
        { bits: "31:0" }
      ],
    },
    { name: "Message_Header_c61",
      desc: "Defines which commanad the message contains",
      swaccess: "rw",
      hwaccess: "none",
      fields: [
        { bits: "31:28" },
        { bits: "27:18",
          name: "Token",
          desc: "must be same for the msg responses associated to a msg whith the same header"
        },
        { bits: "17:10",
          name: "Protocol_Id",
          desc: "Identifies to which protocol the command belongs to"
        },
        { bits: "9:8",
          name: "Message_Type",
          desc: "can be 0,1,2,3 depending on the kind of msg to be sent"
        },
        { bits: "7:0",
          name: "Message_Id",
          desc: "unique identifier for each command availabe in the protocol pointed by protocol_id"
        }
      ],
    },
    { name: "Message_Payload_1_c61",
      desc: "memory region dedicated to the parameters of the commands and their returns",
      swaccess: "rw",
      hwaccess: "none",
      fields: [
        { bits: "31:0" }
      ],
    },
    { name: "Doorbell_c61",
      desc: "Rapresents the interrupt to be raised towards the platform",
      swaccess: "rw",
      hwaccess: "hro",
      fields: [
        { bits: "31:1",
          name: "Preserve_Mask",
          desc: "These bits must be constant to 0, not used with just one platform and one agent"
        },
        { bits: "0",
          name: "intr",
          desc: "Interrupt bit"
        }
      ],
    },
    { name:  "Completion_Interrupt_c61",
      desc: "Rapresent the interrupt the platform should raise when it finishes to execute the received command",
      swaccess: "rw",
      hwaccess: "hro",
      fields: [
        { bits: "31:1",
          name: "Preserve_Mask",
          desc: "These bits must be constant to 0, not used with just one platform and one agent"
        },
        { bits: "0",
          name: "intr",
          desc: "Interrupt bit"
        }
      ],
    },
    { name: "Reserved_1_c62",
      desc: "Reserved, must be 0",
      swaccess: "rw",
      hwaccess: "none",
      fields: [
        { bits: "31:0" }
      ],
    },
    { name: "Channel_Status_c62",
      desc: "Indicates which entity has access to the Shared Memory",
      swaccess: "rw",
      hwaccess: "none",
      fields: [
        { bits: "31:2" },
        { bits: "1",
          name: "channel_error",
          desc: "Must be 0 in absence of errors"
        },
        { bits: "0",
          name: "channel_free",
          desc: "If 1 the agent own the channel, if 0 the platform own the channel"
        }
      ],
    },
    { name: "Reserved_2_c62",
      desc: "Reserved, implementation defined (32 bits over 64)",
      swaccess: "rw",
      hwaccess: "none",
      fields: [
        { bits: "31:0" }
      ],
    },
    { name: "Reserved_3_c62",
      desc: "Reserved, implementation defined (32 bits over 64)",
      swaccess: "none",
      hwaccess: "none",
      fields: [
        { bits: "31:0" }
      ],
    },
    { name: "Channel_Flags_c62",
      desc: "Defines wheter interrupts or polling is used for communication",
      swaccess: "rw",
      hwaccess: "none",
      fields: [
        { bits: "31:1" },
        { bits: "0",
          name: "intr_enable",
          desc: "If 1 interruts are used, if 0 polling is used"
        }
      ],
    },
    { name: "Length_c62",
      desc: "Lenght of payload + header",
      swaccess: "rw",
      hwaccess: "none",
      fields: [
        { bits: "31:0" }
      ],
    },
    { name: "Message_Header_c62",
      desc: "Defines which commanad the message contains",
      swaccess: "rw",
      hwaccess: "none",
      fields: [
        { bits: "31:28" },
        { bits: "27:18",
          name: "Token",
          desc: "must be same for the msg responses associated to a msg whith the same header"
        },
        { bits: "17:10",
          name: "Protocol_Id",
          desc: "Identifies to which protocol the command belongs to"
        },
        { bits: "9:8",
          name: "Message_Type",
          desc: "can be 0,1,2,3 depending on the kind of msg to be sent"
        },
        { bits: "7:0",
          name: "Message_Id",
          desc: "unique identifier for each command availabe in the protocol pointed by protocol_id"
        }
      ],
    },
    { name: "Message_Payload_1_c62",
      desc: "memory region dedicated to the parameters of the commands and their returns",
      swaccess: "rw",
      hwaccess: "none",
      fields: [
        { bits: "31:0" }
      ],
    },
    { name: "Doorbell_c62",
      desc: "Rapresents the interrupt to be raised towards the platform",
      swaccess: "rw",
      hwaccess: "hro",
      fields: [
        { bits: "31:1",
          name: "Preserve_Mask",
          desc: "These bits must be constant to 0, not used with just one platform and one agent"
        },
        { bits: "0",
          name: "intr",
          desc: "Interrupt bit"
        }
      ],
    },
    { name:  "Completion_Interrupt_c62",
      desc: "Rapresent the interrupt the platform should raise when it finishes to execute the received command",
      swaccess: "rw",
      hwaccess: "hro",
      fields: [
        { bits: "31:1",
          name: "Preserve_Mask",
          desc: "These bits must be constant to 0, not used with just one platform and one agent"
        },
        { bits: "0",
          name: "intr",
          desc: "Interrupt bit"
        }
      ],
    },
    { name: "Reserved_1_c63",
      desc: "Reserved, must be 0",
      swaccess: "rw",
      hwaccess: "none",
      fields: [
        { bits: "31:0" }
      ],
    },
    { name: "Channel_Status_c63",
      desc: "Indicates which entity has access to the Shared Memory",
      swaccess: "rw",
      hwaccess: "none",
      fields: [
        { bits: "31:2" },
        { bits: "1",
          name: "channel_error",
          desc: "Must be 0 in absence of errors"
        },
        { bits: "0",
          name: "channel_free",
          desc: "If 1 the agent own the channel, if 0 the platform own the channel"
        }
      ],
    },
    { name: "Reserved_2_c63",
      desc: "Reserved, implementation defined (32 bits over 64)",
      swaccess: "rw",
      hwaccess: "none",
      fields: [
        { bits: "31:0" }
      ],
    },
    { name: "Reserved_3_c63",
      desc: "Reserved, implementation defined (32 bits over 64)",
      swaccess: "none",
      hwaccess: "none",
      fields: [
        { bits: "31:0" }
      ],
    },
    { name: "Channel_Flags_c63",
      desc: "Defines wheter interrupts or polling is used for communication",
      swaccess: "rw",
      hwaccess: "none",
      fields: [
        { bits: "31:1" },
        { bits: "0",
          name: "intr_enable",
          desc: "If 1 interruts are used, if 0 polling is used"
        }
      ],
    },
    { name: "Length_c63",
      desc: "Lenght of payload + header",
      swaccess: "rw",
      hwaccess: "none",
      fields: [
        { bits: "31:0" }
      ],
    },
    { name: "Message_Header_c63",
      desc: "Defines which commanad the message contains",
      swaccess: "rw",
      hwaccess: "none",
      fields: [
        { bits: "31:28" },
        { bits: "27:18",
          name: "Token",
          desc: "must be same for the msg responses associated to a msg whith the same header"
        },
        { bits: "17:10",
          name: "Protocol_Id",
          desc: "Identifies to which protocol the command belongs to"
        },
        { bits: "9:8",
          name: "Message_Type",
          desc: "can be 0,1,2,3 depending on the kind of msg to be sent"
        },
        { bits: "7:0",
          name: "Message_Id",
          desc: "unique identifier for each command availabe in the protocol pointed by protocol_id"
        }
      ],
    },
    { name: "Message_Payload_1_c63",
      desc: "memory region dedicated to the parameters of the commands and their returns",
      swaccess: "rw",
      hwaccess: "none",
      fields: [
        { bits: "31:0" }
      ],
    },
    { name: "Doorbell_c63",
      desc: "Rapresents the interrupt to be raised towards the platform",
      swaccess: "rw",
      hwaccess: "hro",
      fields: [
        { bits: "31:1",
          name: "Preserve_Mask",
          desc: "These bits must be constant to 0, not used with just one platform and one agent"
        },
        { bits: "0",
          name: "intr",
          desc: "Interrupt bit"
        }
      ],
    },
    { name:  "Completion_Interrupt_c63",
      desc: "Rapresent the interrupt the platform should raise when it finishes to execute the received command",
      swaccess: "rw",
      hwaccess: "hro",
      fields: [
        { bits: "31:1",
          name: "Preserve_Mask",
          desc: "These bits must be constant to 0, not used with just one platform and one agent"
        },
        { bits: "0",
          name: "intr",
          desc: "Interrupt bit"
        }
      ],
    },
  ],
}

