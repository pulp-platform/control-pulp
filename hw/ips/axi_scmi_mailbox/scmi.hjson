// Copyright lowRISC contributors.
// Licensed under the Apache License, Version 2.0, see LICENSE for details.
// SPDX-License-Identifier: Apache-2.0
# SCMI register template
# - src: Number of mailbox channels. Following is the memory layout of one channel.
{
  name: "scmi",
  clock_primary: "clk_i",
  bus_interfaces: [
        { protocol: "reg_iface", direction: "device"}
    ],
  regwidth: "32",
  registers: [
    { name: "Reserved_1_c0",
      desc: "Reserved, must be 0",
      swaccess: "rw",
      hwaccess: "none",
      fields: [
        { bits: "31:0" }
      ],
    },
    { name: "Channel_Status_c0",
      desc: "Indicates which entity has access to the Shared Memory",
      swaccess: "rw",
      hwaccess: "none",
      fields: [
        { bits: "31:2" },
        { bits: "1",
          name: "channel_error",
          desc: "Must be 0 in absence of errors"
        },
        { bits: "0",
          name: "channel_free",
          desc: "If 1 the agent own the channel, if 0 the platform own the channel"
        }
      ],
    },
    { name: "Reserved_2_c0",
      desc: "Reserved, implementation defined (32 bits over 64)",
      swaccess: "rw",
      hwaccess: "none",
      fields: [
        { bits: "31:0" }
      ],
    },
    { name: "Reserved_3_c0",
      desc: "Reserved, implementation defined (32 bits over 64)",
      swaccess: "rw",
      hwaccess: "none",
      fields: [
        { bits: "31:0" }
      ],
    },
    { name: "Channel_Flags_c0",
      desc: "Defines wheter interrupts or polling is used for communication",
      swaccess: "rw",
      hwaccess: "none",
      fields: [
        { bits: "31:1" },
        { bits: "0",
          name: "intr_enable",
          desc: "If 1 interruts are used, if 0 polling is used"
        }
      ],
    },
    { name: "Length_c0",
      desc: "Lenght of payload + header",
      swaccess: "rw",
      hwaccess: "none",
      fields: [
        { bits: "31:0" }
      ],
    },
    { name: "Message_Header_c0",
      desc: "Defines which commanad the message contains",
      swaccess: "rw",
      hwaccess: "none",
      fields: [
        { bits: "31:28" },
        { bits: "27:18",
          name: "Token",
          desc: "must be same for the msg responses associated to a msg whith the same header"
        },
        { bits: "17:10",
          name: "Protocol_Id",
          desc: "Identifies to which protocol the command belongs to"
        },
        { bits: "9:8",
          name: "Message_Type",
          desc: "can be 0,1,2,3 depending on the kind of msg to be sent"
        },
        { bits: "7:0",
          name: "Message_Id",
          desc: "unique identifier for each command availabe in the protocol pointed by protocol_id"
        }
      ],
    },
      { name: "Message_Payload_0_c0",
        desc: "memory region dedicated to the parameters of the commands and their returns",
        swaccess: "rw",
        hwaccess: "none",
        fields: [
          { bits: "31:0" }
        ],
      },
      { name: "Message_Payload_1_c0",
        desc: "memory region dedicated to the parameters of the commands and their returns",
        swaccess: "rw",
        hwaccess: "none",
        fields: [
          { bits: "31:0" }
        ],
      },
      { name: "Message_Payload_2_c0",
        desc: "memory region dedicated to the parameters of the commands and their returns",
        swaccess: "rw",
        hwaccess: "none",
        fields: [
          { bits: "31:0" }
        ],
      },
      { name: "Message_Payload_3_c0",
        desc: "memory region dedicated to the parameters of the commands and their returns",
        swaccess: "rw",
        hwaccess: "none",
        fields: [
          { bits: "31:0" }
        ],
      },
      { name: "Message_Payload_4_c0",
        desc: "memory region dedicated to the parameters of the commands and their returns",
        swaccess: "rw",
        hwaccess: "none",
        fields: [
          { bits: "31:0" }
        ],
      },
      { name: "Message_Payload_5_c0",
        desc: "memory region dedicated to the parameters of the commands and their returns",
        swaccess: "rw",
        hwaccess: "none",
        fields: [
          { bits: "31:0" }
        ],
      },
      { name: "Message_Payload_6_c0",
        desc: "memory region dedicated to the parameters of the commands and their returns",
        swaccess: "rw",
        hwaccess: "none",
        fields: [
          { bits: "31:0" }
        ],
      },
      { name: "Message_Payload_7_c0",
        desc: "memory region dedicated to the parameters of the commands and their returns",
        swaccess: "rw",
        hwaccess: "none",
        fields: [
          { bits: "31:0" }
        ],
      },
      { name: "Message_Payload_8_c0",
        desc: "memory region dedicated to the parameters of the commands and their returns",
        swaccess: "rw",
        hwaccess: "none",
        fields: [
          { bits: "31:0" }
        ],
      },
      { name: "Message_Payload_9_c0",
        desc: "memory region dedicated to the parameters of the commands and their returns",
        swaccess: "rw",
        hwaccess: "none",
        fields: [
          { bits: "31:0" }
        ],
      },
      { name: "Message_Payload_10_c0",
        desc: "memory region dedicated to the parameters of the commands and their returns",
        swaccess: "rw",
        hwaccess: "none",
        fields: [
          { bits: "31:0" }
        ],
      },
      { name: "Message_Payload_11_c0",
        desc: "memory region dedicated to the parameters of the commands and their returns",
        swaccess: "rw",
        hwaccess: "none",
        fields: [
          { bits: "31:0" }
        ],
      },
      { name: "Message_Payload_12_c0",
        desc: "memory region dedicated to the parameters of the commands and their returns",
        swaccess: "rw",
        hwaccess: "none",
        fields: [
          { bits: "31:0" }
        ],
      },
      { name: "Message_Payload_13_c0",
        desc: "memory region dedicated to the parameters of the commands and their returns",
        swaccess: "rw",
        hwaccess: "none",
        fields: [
          { bits: "31:0" }
        ],
      },
      { name: "Message_Payload_14_c0",
        desc: "memory region dedicated to the parameters of the commands and their returns",
        swaccess: "rw",
        hwaccess: "none",
        fields: [
          { bits: "31:0" }
        ],
      },
      { name: "Message_Payload_15_c0",
        desc: "memory region dedicated to the parameters of the commands and their returns",
        swaccess: "rw",
        hwaccess: "none",
        fields: [
          { bits: "31:0" }
        ],
      },
      { name: "Message_Payload_16_c0",
        desc: "memory region dedicated to the parameters of the commands and their returns",
        swaccess: "rw",
        hwaccess: "none",
        fields: [
          { bits: "31:0" }
        ],
      },
      { name: "Message_Payload_17_c0",
        desc: "memory region dedicated to the parameters of the commands and their returns",
        swaccess: "rw",
        hwaccess: "none",
        fields: [
          { bits: "31:0" }
        ],
      },
      { name: "Message_Payload_18_c0",
        desc: "memory region dedicated to the parameters of the commands and their returns",
        swaccess: "rw",
        hwaccess: "none",
        fields: [
          { bits: "31:0" }
        ],
      },
      { name: "Message_Payload_19_c0",
        desc: "memory region dedicated to the parameters of the commands and their returns",
        swaccess: "rw",
        hwaccess: "none",
        fields: [
          { bits: "31:0" }
        ],
      },
      { name: "Message_Payload_20_c0",
        desc: "memory region dedicated to the parameters of the commands and their returns",
        swaccess: "rw",
        hwaccess: "none",
        fields: [
          { bits: "31:0" }
        ],
      },
      { name: "Message_Payload_21_c0",
        desc: "memory region dedicated to the parameters of the commands and their returns",
        swaccess: "rw",
        hwaccess: "none",
        fields: [
          { bits: "31:0" }
        ],
      },
      { name: "Message_Payload_22_c0",
        desc: "memory region dedicated to the parameters of the commands and their returns",
        swaccess: "rw",
        hwaccess: "none",
        fields: [
          { bits: "31:0" }
        ],
      },
      { name: "Message_Payload_23_c0",
        desc: "memory region dedicated to the parameters of the commands and their returns",
        swaccess: "rw",
        hwaccess: "none",
        fields: [
          { bits: "31:0" }
        ],
      },
      { name: "Message_Payload_24_c0",
        desc: "memory region dedicated to the parameters of the commands and their returns",
        swaccess: "rw",
        hwaccess: "none",
        fields: [
          { bits: "31:0" }
        ],
      },
      { name: "Message_Payload_25_c0",
        desc: "memory region dedicated to the parameters of the commands and their returns",
        swaccess: "rw",
        hwaccess: "none",
        fields: [
          { bits: "31:0" }
        ],
      },
      { name: "Message_Payload_26_c0",
        desc: "memory region dedicated to the parameters of the commands and their returns",
        swaccess: "rw",
        hwaccess: "none",
        fields: [
          { bits: "31:0" }
        ],
      },
      { name: "Message_Payload_27_c0",
        desc: "memory region dedicated to the parameters of the commands and their returns",
        swaccess: "rw",
        hwaccess: "none",
        fields: [
          { bits: "31:0" }
        ],
      },
      { name: "Message_Payload_28_c0",
        desc: "memory region dedicated to the parameters of the commands and their returns",
        swaccess: "rw",
        hwaccess: "none",
        fields: [
          { bits: "31:0" }
        ],
      },
      { name: "Message_Payload_29_c0",
        desc: "memory region dedicated to the parameters of the commands and their returns",
        swaccess: "rw",
        hwaccess: "none",
        fields: [
          { bits: "31:0" }
        ],
      },
      { name: "Message_Payload_30_c0",
        desc: "memory region dedicated to the parameters of the commands and their returns",
        swaccess: "rw",
        hwaccess: "none",
        fields: [
          { bits: "31:0" }
        ],
      },
      { name: "Message_Payload_31_c0",
        desc: "memory region dedicated to the parameters of the commands and their returns",
        swaccess: "rw",
        hwaccess: "none",
        fields: [
          { bits: "31:0" }
        ],
      },
      { name: "Message_Payload_32_c0",
        desc: "memory region dedicated to the parameters of the commands and their returns",
        swaccess: "rw",
        hwaccess: "none",
        fields: [
          { bits: "31:0" }
        ],
      },
    { name: "Doorbell_c0",
      desc: "Rapresents the interrupt to be raised towards the platform",
      swaccess: "rw",
      hwaccess: "hro",
      fields: [
        { bits: "31:0",
          name: "intr",
          desc: "Interrupt bits"
        }
      ],
    },
    { name:  "Completion_Interrupt_c0",
      desc: "Rapresent the interrupt the platform should raise when it finishes to execute the received command",
      swaccess: "rw",
      hwaccess: "hro",
      fields: [
        { bits: "31:0",
          name: "intr",
          desc: "Interrupt bits"
        }
      ],
    },
  ],
}

